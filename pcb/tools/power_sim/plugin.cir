Maru60 power tree (a) plug-in, averaged buck model
* Source steps from 0 to vsrc in 1 us at t = 1 ms. 3V3 load i33a (appears
* once the rail is above about 2 V), LED rail off. Full-length eFuse ramp
* and soft start.
.include models.lib
.include params.inc
.param cssx={css}
.param kdvdtx={kdvdt}
.include board.inc
Vsrc src 0 pwl(0 0 1m 0 1.001m {vsrc})
XU18 vbk sw fb ss v4 0 tps62932_avg lnom={l2} kea={kea} vref={vref} iss={iss}
Vlen len 0 0
Vi33 i33cmd 0 {i33a}
Vled ledcmd 0 0
Vsh33 sh33 0 0
Vshl shled 0 0
.options method=gear reltol=1e-3 abstol=1e-9 vntol=1e-6 chgtol=1e-15 itl4=200
.ic v(v4)=0 v(v33)=0 v(vprot)=0
.control
set noaskquit
set wr_singlescale
set wr_vecnames
tran 2u 160m 0 20u uic
wrdata out.txt v(src) v(vbus) v(vfused) v(vprot) v(vbk) v(v4) v(v4b) v(v4c) v(v33) v(v33m) v(vled) i(Vsrc) i(L2) v(uvlo) v(ovlo) v(xu18.comp) v(xu8.en) v(dvdt) v(ss) v(avdd) v(xu18.d)
quit
.endc
.end
