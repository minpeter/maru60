* led_hop17_weakp: SK6805 DOUT (assumed 1000 ohm, 30 ns) -> 0.001 ohm in series -> routed hop -> DIN 15 pF
Vsrc src 0 PWL(0.0000n 0 100.0000n 0 130.0000n 4 400.0000n 4 430.0000n 0 1300.0000n 0 1330.0000n 4 2200.0000n 4 2230.0000n 0 2500.0000n 0 2530.0000n 4 2800.0000n 4 2830.0000n 0 3700.0000n 0 3730.0000n 4 4600.0000n 4 4630.0000n 0)
Rdrv src dout 1000.0
Cdout dout 0 2p
Rt4 dout tm2 0.00258
Lt4 tm2 t3 0.410026n
Ct4 t3 0 0.097676p
Rt6 t3 tm5 0.00258
Lt6 tm5 p1 0.410026n
Ct6 p1 0 0.097676p
Rt10 p1 tm8 0.00373554
Lt10 tm8 t9 0.593671n
Ct10 t9 0 0.141424p
Rt12 t9 tm11 0.00373554
Lt12 tm11 p7 0.593671n
Ct12 p7 0 0.141424p
Rt16 p7 tm14 0.00425678
Lt16 tm14 t15 0.676509n
Ct16 t15 0 0.161157p
Rt18 t15 tm17 0.00425678
Lt18 tm17 p13 0.676509n
Ct18 p13 0 0.161157p
Rt21 p13 tm20 0.000122857
Lt21 tm20 p19 0.0195251n
Ct21 p19 0 0.00465124p
Rt23 p19 tm22 0.00208495
Lt23 tm22 rs_a 0.331351n
Ct23 rs_a 0 0.0789342p
Rser rs_a rs_b 0.001
Cser rs_b 0 0.1p
Rt26 rs_b tm25 0.00331714
Lt26 tm25 p24 0.527177n
Ct26 p24 0 0.125583p
Rt29 p24 tm28 0.000868731
Lt29 tm28 p27 0.138063n
Ct29 p27 0 0.0328892p
Rt32 p27 tm30 0.00480694
Lt32 tm30 t31 0.763943n
Ct32 t31 0 0.181986p
Rt35 t31 tm33 0.00480694
Lt35 tm33 t34 0.763943n
Ct35 t34 0 0.181986p
Rt38 t34 tm36 0.00480694
Lt38 tm36 t37 0.763943n
Ct38 t37 0 0.181986p
Rt41 t37 tm39 0.00480694
Lt41 tm39 t40 0.763943n
Ct41 t40 0 0.181986p
Rt44 t40 tm42 0.00480694
Lt44 tm42 t43 0.763943n
Ct44 t43 0 0.181986p
Rt47 t43 tm45 0.00480694
Lt47 tm45 t46 0.763943n
Ct47 t46 0 0.181986p
Rt50 t46 tm48 0.00480694
Lt50 tm48 t49 0.763943n
Ct50 t49 0 0.181986p
Rt53 t49 tm51 0.00480694
Lt53 tm51 t52 0.763943n
Ct53 t52 0 0.181986p
Rt56 t52 tm54 0.00480694
Lt56 tm54 t55 0.763943n
Ct56 t55 0 0.181986p
Rt59 t55 tm57 0.00480694
Lt59 tm57 t58 0.763943n
Ct59 t58 0 0.181986p
Rt62 t58 tm60 0.00480694
Lt62 tm60 t61 0.763943n
Ct62 t61 0 0.181986p
Rt65 t61 tm63 0.00480694
Lt65 tm63 t64 0.763943n
Ct65 t64 0 0.181986p
Rt68 t64 tm66 0.00480694
Lt68 tm66 t67 0.763943n
Ct68 t67 0 0.181986p
Rt71 t67 tm69 0.00480694
Lt71 tm69 t70 0.763943n
Ct71 t70 0 0.181986p
Rt74 t70 tm72 0.00480694
Lt74 tm72 t73 0.763943n
Ct74 t73 0 0.181986p
Rt77 t73 tm75 0.00480694
Lt77 tm75 t76 0.763943n
Ct77 t76 0 0.181986p
Rt80 t76 tm78 0.00480694
Lt80 tm78 t79 0.763943n
Ct80 t79 0 0.181986p
Rt83 t79 tm81 0.00480694
Lt83 tm81 t82 0.763943n
Ct83 t82 0 0.181986p
Rt86 t82 tm84 0.00480694
Lt86 tm84 t85 0.763943n
Ct86 t85 0 0.181986p
Rt89 t85 tm87 0.00480694
Lt89 tm87 t88 0.763943n
Ct89 t88 0 0.181986p
Rt92 t88 tm90 0.00480694
Lt92 tm90 t91 0.763943n
Ct92 t91 0 0.181986p
Rt95 t91 tm93 0.00480694
Lt95 tm93 t94 0.763943n
Ct95 t94 0 0.181986p
Rt98 t94 tm96 0.00480694
Lt98 tm96 t97 0.763943n
Ct98 t97 0 0.181986p
Rt101 t97 tm99 0.00480694
Lt101 tm99 t100 0.763943n
Ct101 t100 0 0.181986p
Rt104 t100 tm102 0.00480694
Lt104 tm102 t103 0.763943n
Ct104 t103 0 0.181986p
Rt107 t103 tm105 0.00480694
Lt107 tm105 t106 0.763943n
Ct107 t106 0 0.181986p
Rt110 t106 tm108 0.00480694
Lt110 tm108 t109 0.763943n
Ct110 t109 0 0.181986p
Rt113 t109 tm111 0.00480694
Lt113 tm111 t112 0.763943n
Ct113 t112 0 0.181986p
Rt116 t112 tm114 0.00480694
Lt116 tm114 t115 0.763943n
Ct116 t115 0 0.181986p
Rt119 t115 tm117 0.00480694
Lt119 tm117 t118 0.763943n
Ct119 t118 0 0.181986p
Rt122 t118 tm120 0.00480694
Lt122 tm120 t121 0.763943n
Ct122 t121 0 0.181986p
Rt125 t121 tm123 0.00480694
Lt125 tm123 t124 0.763943n
Ct125 t124 0 0.181986p
Rt128 t124 tm126 0.00480694
Lt128 tm126 t127 0.763943n
Ct128 t127 0 0.181986p
Rt131 t127 tm129 0.00480694
Lt131 tm129 t130 0.763943n
Ct131 t130 0 0.181986p
Rt134 t130 tm132 0.00480694
Lt134 tm132 t133 0.763943n
Ct134 t133 0 0.181986p
Rt136 t133 tm135 0.00480694
Lt136 tm135 din 0.763943n
Ct136 din 0 0.181986p
Cin din 0 15p
.tran 0.1n 5000n 0 0.2n
.control
set wr_singlescale
set wr_vecnames
set numdgt=7
run

wrdata /out/led_hop17_weakp.txt v(dout) v(din)
.endc
.end
