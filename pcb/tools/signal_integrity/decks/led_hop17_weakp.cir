* led_hop17_weakp: SK6805 DOUT (assumed 1000 ohm, 30 ns) -> 100 ohm in series -> routed hop -> DIN 15 pF
Vsrc src 0 PWL(0.0000n 0 100.0000n 0 130.0000n 4 400.0000n 4 430.0000n 0 1300.0000n 0 1330.0000n 4 2200.0000n 4 2230.0000n 0 2500.0000n 0 2530.0000n 4 2800.0000n 4 2830.0000n 0 3700.0000n 0 3730.0000n 4 4600.0000n 4 4630.0000n 0)
Rdrv src dout 1000.0
Cdout dout 0 2p
Rt4 dout tm2 0.00277994
Lt4 tm2 t3 0.441802n
Ct4 t3 0 0.105246p
Rt6 t3 tm5 0.00277994
Lt6 tm5 p1 0.441802n
Ct6 p1 0 0.105246p
Rt10 p1 tm8 0.00347492
Lt10 tm8 t9 0.552252n
Ct10 t9 0 0.131557p
Rt13 t9 tm11 0.00347492
Lt13 tm11 t12 0.552252n
Ct13 t12 0 0.131557p
Rt15 t12 tm14 0.00347492
Lt15 tm14 p7 0.552252n
Ct15 p7 0 0.131557p
Rt18 p7 tm17 0.00208495
Lt18 tm17 p16 0.331351n
Ct18 p16 0 0.0789342p
Rt21 p16 tm19 0.00347492
Lt21 tm19 t20 0.552252n
Ct21 t20 0 0.131557p
Rt23 t20 tm22 0.00347492
Lt23 tm22 rs_a 0.552252n
Ct23 rs_a 0 0.131557p
Rser rs_a rs_b 100
Cser rs_b 0 0.1p
Rt26 rs_b tm25 0.00121622
Lt26 tm25 p24 0.193288n
Ct26 p24 0 0.0460449p
Rt29 p24 tm28 0.000122857
Lt29 tm28 p27 0.0195251n
Ct29 p27 0 0.00465124p
Rt32 p27 tm31 0.000694985
Lt32 tm31 p30 0.11045n
Ct32 p30 0 0.0263114p
Rt35 p30 tm33 0.00464715
Lt35 tm33 t34 0.738549n
Ct35 t34 0 0.175936p
Rt38 t34 tm36 0.00464715
Lt38 tm36 t37 0.738549n
Ct38 t37 0 0.175936p
Rt41 t37 tm39 0.00464715
Lt41 tm39 t40 0.738549n
Ct41 t40 0 0.175936p
Rt44 t40 tm42 0.00464715
Lt44 tm42 t43 0.738549n
Ct44 t43 0 0.175936p
Rt47 t43 tm45 0.00464715
Lt47 tm45 t46 0.738549n
Ct47 t46 0 0.175936p
Rt50 t46 tm48 0.00464715
Lt50 tm48 t49 0.738549n
Ct50 t49 0 0.175936p
Rt53 t49 tm51 0.00464715
Lt53 tm51 t52 0.738549n
Ct53 t52 0 0.175936p
Rt56 t52 tm54 0.00464715
Lt56 tm54 t55 0.738549n
Ct56 t55 0 0.175936p
Rt59 t55 tm57 0.00464715
Lt59 tm57 t58 0.738549n
Ct59 t58 0 0.175936p
Rt62 t58 tm60 0.00464715
Lt62 tm60 t61 0.738549n
Ct62 t61 0 0.175936p
Rt65 t61 tm63 0.00464715
Lt65 tm63 t64 0.738549n
Ct65 t64 0 0.175936p
Rt67 t64 tm66 0.00464715
Lt67 tm66 din 0.738549n
Ct67 din 0 0.175936p
Cin din 0 15p
.tran 0.1n 5000n 0 0.2n
.control
set wr_singlescale
set wr_vecnames
set numdgt=7
run

wrdata /out/led_hop17_weakp.txt v(dout) v(din)
.endc
.end
