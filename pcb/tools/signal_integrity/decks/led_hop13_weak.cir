* led_hop13_weak: SK6805 DOUT (assumed 500 ohm, 30 ns) -> 100 ohm in series -> routed hop -> DIN 5 pF
Vsrc src 0 PWL(0.0000n 0 100.0000n 0 130.0000n 4 400.0000n 4 430.0000n 0 1300.0000n 0 1330.0000n 4 2200.0000n 4 2230.0000n 0 2500.0000n 0 2530.0000n 4 2800.0000n 4 2830.0000n 0 3700.0000n 0 3730.0000n 4 4600.0000n 4 4630.0000n 0)
Rdrv src dout 500.0
Cdout dout 0 2p
Rt2 dout tm1 0.00416991
Lt2 tm1 rs_a 0.560331n
Ct2 rs_a 0 0.103897p
Rser rs_a rs_b 100
Cser rs_b 0 0.1p
Rt6 rs_b tm4 0.00556567
Lt6 tm4 t5 0.747886n
Ct6 t5 0 0.138673p
Rt8 t5 tm7 0.00556567
Lt8 tm7 p3 0.747886n
Ct8 p3 0 0.138673p
Lv10 p3 v9 1.358n
Cv10 v9 0 0.4885p
Rt14 v9 tm12 0.00579295
Lt14 tm12 t13 0.778427n
Ct14 t13 0 0.144336p
Rt17 t13 tm15 0.00579295
Lt17 tm15 t16 0.778427n
Ct17 t16 0 0.144336p
Rt20 t16 tm18 0.00579295
Lt20 tm18 t19 0.778427n
Ct20 t19 0 0.144336p
Rt22 t19 tm21 0.00579295
Lt22 tm21 p11 0.778427n
Ct22 p11 0 0.144336p
Lv24 p11 v23 1.358n
Cv24 v23 0 0.4885p
Rt27 v23 tm25 0.00647276
Lt27 tm25 t26 0.869777n
Ct27 t26 0 0.161274p
Rt30 t26 tm28 0.00647276
Lt30 tm28 t29 0.869777n
Ct30 t29 0 0.161274p
Rt33 t29 tm31 0.00647276
Lt33 tm31 t32 0.869777n
Ct33 t32 0 0.161274p
Rt36 t32 tm34 0.00647276
Lt36 tm34 t35 0.869777n
Ct36 t35 0 0.161274p
Rt39 t35 tm37 0.00647276
Lt39 tm37 t38 0.869777n
Ct39 t38 0 0.161274p
Rt42 t38 tm40 0.00647276
Lt42 tm40 t41 0.869777n
Ct42 t41 0 0.161274p
Rt45 t41 tm43 0.00647276
Lt45 tm43 t44 0.869777n
Ct45 t44 0 0.161274p
Rt48 t44 tm46 0.00647276
Lt48 tm46 t47 0.869777n
Ct48 t47 0 0.161274p
Rt51 t47 tm49 0.00647276
Lt51 tm49 t50 0.869777n
Ct51 t50 0 0.161274p
Rt54 t50 tm52 0.00647276
Lt54 tm52 t53 0.869777n
Ct54 t53 0 0.161274p
Rt57 t53 tm55 0.00647276
Lt57 tm55 t56 0.869777n
Ct57 t56 0 0.161274p
Rt60 t56 tm58 0.00647276
Lt60 tm58 t59 0.869777n
Ct60 t59 0 0.161274p
Rt63 t59 tm61 0.00647276
Lt63 tm61 t62 0.869777n
Ct63 t62 0 0.161274p
Rt66 t62 tm64 0.00647276
Lt66 tm64 t65 0.869777n
Ct66 t65 0 0.161274p
Rt69 t65 tm67 0.00647276
Lt69 tm67 t68 0.869777n
Ct69 t68 0 0.161274p
Rt72 t68 tm70 0.00647276
Lt72 tm70 t71 0.869777n
Ct72 t71 0 0.161274p
Rt75 t71 tm73 0.00647276
Lt75 tm73 t74 0.869777n
Ct75 t74 0 0.161274p
Rt78 t74 tm76 0.00647276
Lt78 tm76 t77 0.869777n
Ct78 t77 0 0.161274p
Rt81 t77 tm79 0.00647276
Lt81 tm79 t80 0.869777n
Ct81 t80 0 0.161274p
Rt84 t80 tm82 0.00647276
Lt84 tm82 t83 0.869777n
Ct84 t83 0 0.161274p
Rt87 t83 tm85 0.00647276
Lt87 tm85 t86 0.869777n
Ct87 t86 0 0.161274p
Rt90 t86 tm88 0.00647276
Lt90 tm88 t89 0.869777n
Ct90 t89 0 0.161274p
Rt93 t89 tm91 0.00647276
Lt93 tm91 t92 0.869777n
Ct93 t92 0 0.161274p
Rt96 t92 tm94 0.00647276
Lt96 tm94 t95 0.869777n
Ct96 t95 0 0.161274p
Rt99 t95 tm97 0.00647276
Lt99 tm97 t98 0.869777n
Ct99 t98 0 0.161274p
Rt102 t98 tm100 0.00647276
Lt102 tm100 t101 0.869777n
Ct102 t101 0 0.161274p
Rt104 t101 tm103 0.00647276
Lt104 tm103 din 0.869777n
Ct104 din 0 0.161274p
Cin din 0 5p
.tran 0.1n 5000n 0 0.2n
.control
set wr_singlescale
set wr_vecnames
set numdgt=7
run

wrdata /out/led_hop13_weak.txt v(dout) v(din)
.endc
.end
