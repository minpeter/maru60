* led_sweep: SK6805 DOUT (assumed 100 ohm, 10 ns) -> routed hop -> DIN 5 pF
Vsrc src 0 PWL(0.0000n 0 100.0000n 0 110.0000n 4 400.0000n 4 410.0000n 0 1300.0000n 0 1310.0000n 4 2200.0000n 4 2210.0000n 0 2500.0000n 0 2510.0000n 4 2800.0000n 4 2810.0000n 0 3700.0000n 0 3710.0000n 4 4600.0000n 4 4610.0000n 0)
Rdrv src dout 100.0
Cdout dout 0 2p
Rt3 dout tm1 0.00467554
Lt3 tm1 t2 0.74306n
Ct3 t2 0 0.177011p
Rt6 t2 tm4 0.00467554
Lt6 tm4 t5 0.74306n
Ct6 t5 0 0.177011p
Rt9 t5 tm7 0.00467554
Lt9 tm7 t8 0.74306n
Ct9 t8 0 0.177011p
Rt12 t8 tm10 0.00467554
Lt12 tm10 t11 0.74306n
Ct12 t11 0 0.177011p
Rt15 t11 tm13 0.00467554
Lt15 tm13 t14 0.74306n
Ct15 t14 0 0.177011p
Rt18 t14 tm16 0.00467554
Lt18 tm16 t17 0.74306n
Ct18 t17 0 0.177011p
Rt21 t17 tm19 0.00467554
Lt21 tm19 t20 0.74306n
Ct21 t20 0 0.177011p
Rt24 t20 tm22 0.00467554
Lt24 tm22 t23 0.74306n
Ct24 t23 0 0.177011p
Rt27 t23 tm25 0.00467554
Lt27 tm25 t26 0.74306n
Ct27 t26 0 0.177011p
Rt30 t26 tm28 0.00467554
Lt30 tm28 t29 0.74306n
Ct30 t29 0 0.177011p
Rt33 t29 tm31 0.00467554
Lt33 tm31 t32 0.74306n
Ct33 t32 0 0.177011p
Rt36 t32 tm34 0.00467554
Lt36 tm34 t35 0.74306n
Ct36 t35 0 0.177011p
Rt39 t35 tm37 0.00467554
Lt39 tm37 t38 0.74306n
Ct39 t38 0 0.177011p
Rt41 t38 tm40 0.00467554
Lt41 tm40 din 0.74306n
Ct41 din 0 0.177011p
Cin din 0 5p
.tran 0.1n 5000n 0 0.2n
.control
set wr_singlescale
set wr_vecnames
set numdgt=7
run

wrdata /out/led_sweep.txt v(dout) v(din)
.endc
.end
