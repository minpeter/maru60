* led_sweep: SK6805 DOUT (assumed 100 ohm, 10 ns) -> routed hop -> DIN 5 pF
Vsrc src 0 PWL(0.0000n 0 100.0000n 0 110.0000n 4 400.0000n 4 410.0000n 0 1300.0000n 0 1310.0000n 4 2200.0000n 4 2210.0000n 0 2500.0000n 0 2510.0000n 4 2800.0000n 4 2810.0000n 0 3700.0000n 0 3710.0000n 4 4600.0000n 4 4610.0000n 0)
Rdrv src dout 100.0
Cdout dout 0 2p
Rt3 dout tm2 0.00416991
Lt3 tm2 p1 0.560331n
Ct3 p1 0 0.103897p
Lv5 p1 v4 1.358n
Cv5 v4 0 0.4885p
Rt9 v4 tm7 0.00579295
Lt9 tm7 t8 0.778427n
Ct9 t8 0 0.144336p
Rt12 t8 tm10 0.00579295
Lt12 tm10 t11 0.778427n
Ct12 t11 0 0.144336p
Rt15 t11 tm13 0.00579295
Lt15 tm13 t14 0.778427n
Ct15 t14 0 0.144336p
Rt17 t14 tm16 0.00579295
Lt17 tm16 p6 0.778427n
Ct17 p6 0 0.144336p
Lv19 p6 v18 1.358n
Cv19 v18 0 0.4885p
Rt22 v18 tm20 0.00647276
Lt22 tm20 t21 0.869777n
Ct22 t21 0 0.161274p
Rt25 t21 tm23 0.00647276
Lt25 tm23 t24 0.869777n
Ct25 t24 0 0.161274p
Rt28 t24 tm26 0.00647276
Lt28 tm26 t27 0.869777n
Ct28 t27 0 0.161274p
Rt31 t27 tm29 0.00647276
Lt31 tm29 t30 0.869777n
Ct31 t30 0 0.161274p
Rt34 t30 tm32 0.00647276
Lt34 tm32 t33 0.869777n
Ct34 t33 0 0.161274p
Rt37 t33 tm35 0.00647276
Lt37 tm35 t36 0.869777n
Ct37 t36 0 0.161274p
Rt40 t36 tm38 0.00647276
Lt40 tm38 t39 0.869777n
Ct40 t39 0 0.161274p
Rt43 t39 tm41 0.00647276
Lt43 tm41 t42 0.869777n
Ct43 t42 0 0.161274p
Rt46 t42 tm44 0.00647276
Lt46 tm44 t45 0.869777n
Ct46 t45 0 0.161274p
Rt49 t45 tm47 0.00647276
Lt49 tm47 t48 0.869777n
Ct49 t48 0 0.161274p
Rt52 t48 tm50 0.00647276
Lt52 tm50 t51 0.869777n
Ct52 t51 0 0.161274p
Rt55 t51 tm53 0.00647276
Lt55 tm53 t54 0.869777n
Ct55 t54 0 0.161274p
Rt58 t54 tm56 0.00647276
Lt58 tm56 t57 0.869777n
Ct58 t57 0 0.161274p
Rt61 t57 tm59 0.00647276
Lt61 tm59 t60 0.869777n
Ct61 t60 0 0.161274p
Rt64 t60 tm62 0.00647276
Lt64 tm62 t63 0.869777n
Ct64 t63 0 0.161274p
Rt67 t63 tm65 0.00647276
Lt67 tm65 t66 0.869777n
Ct67 t66 0 0.161274p
Rt70 t66 tm68 0.00647276
Lt70 tm68 t69 0.869777n
Ct70 t69 0 0.161274p
Rt73 t69 tm71 0.00647276
Lt73 tm71 t72 0.869777n
Ct73 t72 0 0.161274p
Rt76 t72 tm74 0.00647276
Lt76 tm74 t75 0.869777n
Ct76 t75 0 0.161274p
Rt79 t75 tm77 0.00647276
Lt79 tm77 t78 0.869777n
Ct79 t78 0 0.161274p
Rt82 t78 tm80 0.00647276
Lt82 tm80 t81 0.869777n
Ct82 t81 0 0.161274p
Rt85 t81 tm83 0.00647276
Lt85 tm83 t84 0.869777n
Ct85 t84 0 0.161274p
Rt88 t84 tm86 0.00647276
Lt88 tm86 t87 0.869777n
Ct88 t87 0 0.161274p
Rt91 t87 tm89 0.00647276
Lt91 tm89 t90 0.869777n
Ct91 t90 0 0.161274p
Rt94 t90 tm92 0.00647276
Lt94 tm92 t93 0.869777n
Ct94 t93 0 0.161274p
Rt97 t93 tm95 0.00647276
Lt97 tm95 t96 0.869777n
Ct97 t96 0 0.161274p
Rt99 t96 tm98 0.00647276
Lt99 tm98 din 0.869777n
Ct99 din 0 0.161274p
Cin din 0 5p
.tran 0.1n 5000n 0 0.2n
.control
set wr_singlescale
set wr_vecnames
set numdgt=7
run

wrdata /out/led_sweep.txt v(dout) v(din)
.endc
.end
