* led_hop26_fast: SK6805 DOUT (assumed 20 ohm, 2 ns) -> 100 ohm in series -> routed hop -> DIN 5 pF
Vsrc src 0 PWL(0.0000n 0 100.0000n 0 102.0000n 4 400.0000n 4 402.0000n 0 1300.0000n 0 1302.0000n 4 2200.0000n 4 2202.0000n 0 2500.0000n 0 2502.0000n 4 2800.0000n 4 2802.0000n 0 3700.0000n 0 3702.0000n 4 4600.0000n 4 4602.0000n 0)
Rdrv src dout 20.0
Cdout dout 0 2p
Rt3 dout tm2 0.000982857
Lt3 tm2 p1 0.156201n
Ct3 p1 0 0.0372099p
Rt6 p1 tm5 0.000347492
Lt6 tm5 p4 0.0552252n
Ct6 p4 0 0.0131557p
Rt9 p4 tm8 0.000245714
Lt9 tm8 p7 0.0390501n
Ct9 p7 0 0.00930248p
Rt13 p7 tm11 0.00622931
Lt13 tm11 t12 0.837062n
Ct13 t12 0 0.155208p
Rt16 t12 tm14 0.00622931
Lt16 tm14 t15 0.837062n
Ct16 t15 0 0.155208p
Rt18 t15 tm17 0.00622931
Lt18 tm17 p10 0.837062n
Ct18 p10 0 0.155208p
Rt21 p10 tm20 0.000347492
Lt21 tm20 p19 0.0552252n
Ct21 p19 0 0.0131557p
Rt24 p19 tm23 0.00122857
Lt24 tm23 p22 0.195251n
Ct24 p22 0 0.0465124p
Rt27 p22 tm26 0.00420907
Lt27 tm26 p25 0.668926n
Ct27 p25 0 0.159351p
Rs31 p25 sm29 0.00455698
Ls31 sm29 s30 0.724217n
Cs31 s30 0 0.172522p
Rs34 s30 sm32 0.00455698
Ls34 sm32 s33 0.724217n
Cs34 s33 0 0.172522p
Rs37 s33 sm35 0.00455698
Ls37 sm35 s36 0.724217n
Cs37 s36 0 0.172522p
Rs40 s36 sm38 0.00455698
Ls40 sm38 s39 0.724217n
Cs40 s39 0 0.172522p
Rs43 s39 sm41 0.00455698
Ls43 sm41 s42 0.724217n
Cs43 s42 0 0.172522p
Rs46 s42 sm44 0.00455698
Ls46 sm44 s45 0.724217n
Cs46 s45 0 0.172522p
Rs49 s45 sm47 0.00455698
Ls49 sm47 s48 0.724217n
Cs49 s48 0 0.172522p
Rs52 s48 sm50 0.00455698
Ls52 sm50 s51 0.724217n
Cs52 s51 0 0.172522p
Rs55 s51 sm53 0.00455698
Ls55 sm53 s54 0.724217n
Cs55 s54 0 0.172522p
Rs58 s54 sm56 0.00455698
Ls58 sm56 s57 0.724217n
Cs58 s57 0 0.172522p
Rs61 s57 sm59 0.00455698
Ls61 sm59 s60 0.724217n
Cs61 s60 0 0.172522p
Rs63 s60 sm62 0.00455698
Ls63 sm62 stubend28 0.724217n
Cs63 stubend28 0 0.172522p
Cs64 stubend28 0 0.15p
Rt67 p25 tm66 8.44463e-06
Lt67 tm66 p65 0.00134206n
Ct67 p65 0 0.000319705p
Rt70 p65 tm69 0.0044698
Lt70 tm69 p68 0.710362n
Ct70 p68 0 0.169222p
Rt74 p68 tm72 0.00405429
Lt74 tm72 t73 0.644327n
Ct74 t73 0 0.153491p
Rt76 t73 tm75 0.00405429
Lt76 tm75 p71 0.644327n
Ct76 p71 0 0.153491p
Rt80 p71 tm78 0.00319429
Lt80 tm78 t79 0.507652n
Ct80 t79 0 0.120932p
Rt82 t79 tm81 0.00319429
Lt82 tm81 p77 0.507652n
Ct82 p77 0 0.120932p
Rt85 p77 tm84 0.00355924
Lt85 tm84 p83 0.565652n
Ct85 p83 0 0.134749p
Lv87 p83 v86 1.358n
Cv87 v86 0 0.4885p
Rt89 v86 tm88 0.00393119
Lt89 tm88 rs_a 0.624764n
Ct89 rs_a 0 0.148831p
Rser rs_a rs_b 100
Cser rs_b 0 0.1p
Rt92 rs_b tm91 0.001204
Lt92 tm91 p90 0.191346n
Ct92 p90 0 0.0455821p
Rs96 p90 sm94 0.00420786
Ls96 sm94 s95 0.668733n
Cs96 s95 0 0.159305p
Rs99 s95 sm97 0.00420786
Ls99 sm97 s98 0.668733n
Cs99 s98 0 0.159305p
Rs102 s98 sm100 0.00420786
Ls102 sm100 s101 0.668733n
Cs102 s101 0 0.159305p
Rs104 s101 sm103 0.00420786
Ls104 sm103 stubend93 0.668733n
Cs104 stubend93 0 0.159305p
Cs105 stubend93 0 0.4885p
Cs106 stubend93 0 0.15p
Rt109 p90 tm108 9.98773e-06
Lt109 tm108 p107 0.0015873n
Ct109 p107 0 0.000378125p
Rt112 p107 tm110 0.00385771
Lt112 tm110 t111 0.700919n
Ct112 t111 0 0.201895p
Rt115 t111 tm113 0.00385771
Lt115 tm113 t114 0.700919n
Ct115 t114 0 0.201895p
Rt118 t114 tm116 0.00385771
Lt118 tm116 t117 0.700919n
Ct118 t117 0 0.201895p
Rt121 t117 tm119 0.00385771
Lt121 tm119 t120 0.700919n
Ct121 t120 0 0.201895p
Rt124 t120 tm122 0.00385771
Lt124 tm122 t123 0.700919n
Ct124 t123 0 0.201895p
Rt127 t123 tm125 0.00385771
Lt127 tm125 t126 0.700919n
Ct127 t126 0 0.201895p
Rt130 t126 tm128 0.00385771
Lt130 tm128 t129 0.700919n
Ct130 t129 0 0.201895p
Rt132 t129 tm131 0.00385771
Lt132 tm131 din 0.700919n
Ct132 din 0 0.201895p
Cin din 0 5p
.tran 0.1n 5000n 0 0.2n
.control
set wr_singlescale
set wr_vecnames
set numdgt=7
run

wrdata /out/led_hop26_fast.txt v(dout) v(din)
.endc
.end
