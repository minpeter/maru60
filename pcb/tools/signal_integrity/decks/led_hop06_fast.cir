* led_hop06_fast: SK6805 DOUT (assumed 20 ohm, 2 ns) -> routed hop -> DIN 5 pF
Vsrc src 0 PWL(0.0000n 0 100.0000n 0 102.0000n 4 400.0000n 4 402.0000n 0 1300.0000n 0 1302.0000n 4 2200.0000n 4 2202.0000n 0 2500.0000n 0 2502.0000n 4 2800.0000n 4 2802.0000n 0 3700.0000n 0 3702.0000n 4 4600.0000n 4 4602.0000n 0)
Rdrv src dout 20.0
Cdout dout 0 2p
Rt3 dout tm2 0.00157606
Lt3 tm2 p1 0.250476n
Ct3 p1 0 0.0596681p
Rt7 p1 tm5 0.00622931
Lt7 tm5 t6 0.837062n
Ct7 t6 0 0.155208p
Rt10 t6 tm8 0.00622931
Lt10 tm8 t9 0.837062n
Ct10 t9 0 0.155208p
Rt12 t9 tm11 0.00622931
Lt12 tm11 p4 0.837062n
Ct12 p4 0 0.155208p
Rt16 p4 tm14 0.00289257
Lt16 tm14 t15 0.459701n
Ct16 t15 0 0.10951p
Rt18 t15 tm17 0.00289257
Lt18 tm17 p13 0.459701n
Ct18 p13 0 0.10951p
Rs22 p13 sm20 0.00455698
Ls22 sm20 s21 0.724217n
Cs22 s21 0 0.172522p
Rs25 s21 sm23 0.00455698
Ls25 sm23 s24 0.724217n
Cs25 s24 0 0.172522p
Rs28 s24 sm26 0.00455698
Ls28 sm26 s27 0.724217n
Cs28 s27 0 0.172522p
Rs31 s27 sm29 0.00455698
Ls31 sm29 s30 0.724217n
Cs31 s30 0 0.172522p
Rs34 s30 sm32 0.00455698
Ls34 sm32 s33 0.724217n
Cs34 s33 0 0.172522p
Rs37 s33 sm35 0.00455698
Ls37 sm35 s36 0.724217n
Cs37 s36 0 0.172522p
Rs40 s36 sm38 0.00455698
Ls40 sm38 s39 0.724217n
Cs40 s39 0 0.172522p
Rs43 s39 sm41 0.00455698
Ls43 sm41 s42 0.724217n
Cs43 s42 0 0.172522p
Rs46 s42 sm44 0.00455698
Ls46 sm44 s45 0.724217n
Cs46 s45 0 0.172522p
Rs49 s45 sm47 0.00455698
Ls49 sm47 s48 0.724217n
Cs49 s48 0 0.172522p
Rs52 s48 sm50 0.00455698
Ls52 sm50 s51 0.724217n
Cs52 s51 0 0.172522p
Rs54 s51 sm53 0.00455698
Ls54 sm53 stubend19 0.724217n
Cs54 stubend19 0 0.172522p
Cs55 stubend19 0 0.15p
Rt59 p13 tm57 0.00466857
Lt59 tm57 t58 0.741952n
Ct59 t58 0 0.176747p
Rt62 t58 tm60 0.00466857
Lt62 tm60 t61 0.741952n
Ct62 t61 0 0.176747p
Rt65 t61 tm63 0.00466857
Lt65 tm63 t64 0.741952n
Ct65 t64 0 0.176747p
Rt68 t64 tm66 0.00466857
Lt68 tm66 t67 0.741952n
Ct68 t67 0 0.176747p
Rt71 t67 tm69 0.00466857
Lt71 tm69 t70 0.741952n
Ct71 t70 0 0.176747p
Rt74 t70 tm72 0.00466857
Lt74 tm72 t73 0.741952n
Ct74 t73 0 0.176747p
Rt76 t73 tm75 0.00466857
Lt76 tm75 p56 0.741952n
Ct76 p56 0 0.176747p
Rs80 p56 sm78 0.00446381
Ls80 sm78 s79 0.709411n
Cs80 s79 0 0.168995p
Rs83 s79 sm81 0.00446381
Ls83 sm81 s82 0.709411n
Cs83 s82 0 0.168995p
Rs85 s82 sm84 0.00446381
Ls85 sm84 stubend77 0.709411n
Cs85 stubend77 0 0.168995p
Cs86 stubend77 0 0.15p
Rt89 p56 tm88 5.99214e-06
Lt89 tm88 p87 0.000952301n
Ct89 p87 0 0.000226856p
Lv91 p87 v90 1.358n
Cv91 v90 0 0.4885p
Rt94 v90 tm92 0.00373486
Lt94 tm92 t93 0.678597n
Ct94 t93 0 0.195465p
Rt97 t93 tm95 0.00373486
Lt97 tm95 t96 0.678597n
Ct97 t96 0 0.195465p
Rt100 t96 tm98 0.00373486
Lt100 tm98 t99 0.678597n
Ct100 t99 0 0.195465p
Rt103 t99 tm101 0.00373486
Lt103 tm101 t102 0.678597n
Ct103 t102 0 0.195465p
Rt106 t102 tm104 0.00373486
Lt106 tm104 t105 0.678597n
Ct106 t105 0 0.195465p
Rt109 t105 tm107 0.00373486
Lt109 tm107 t108 0.678597n
Ct109 t108 0 0.195465p
Rt112 t108 tm110 0.00373486
Lt112 tm110 t111 0.678597n
Ct112 t111 0 0.195465p
Rt115 t111 tm113 0.00373486
Lt115 tm113 t114 0.678597n
Ct115 t114 0 0.195465p
Rt117 t114 tm116 0.00373486
Lt117 tm116 din 0.678597n
Ct117 din 0 0.195465p
Cin din 0 5p
.tran 0.1n 5000n 0 0.2n
.control
set wr_singlescale
set wr_vecnames
set numdgt=7
run

wrdata /out/led_hop06_fast.txt v(dout) v(din)
.endc
.end
