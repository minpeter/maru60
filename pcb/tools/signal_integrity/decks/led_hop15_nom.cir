* led_hop15_nom: SK6805 DOUT (assumed 100 ohm, 10 ns) -> 100 ohm in series -> routed hop -> DIN 5 pF
Vsrc src 0 PWL(0.0000n 0 100.0000n 0 110.0000n 4 400.0000n 4 410.0000n 0 1300.0000n 0 1310.0000n 4 2200.0000n 4 2210.0000n 0 2500.0000n 0 2510.0000n 4 2800.0000n 4 2810.0000n 0 3700.0000n 0 3710.0000n 4 4600.0000n 4 4610.0000n 0)
Rdrv src dout 100.0
Cdout dout 0 2p
Rt3 dout tm2 0.000982857
Lt3 tm2 p1 0.156201n
Ct3 p1 0 0.0372099p
Rt6 p1 tm5 0.000347492
Lt6 tm5 p4 0.0552252n
Ct6 p4 0 0.0131557p
Rt9 p4 tm8 0.000245714
Lt9 tm8 p7 0.0390501n
Ct9 p7 0 0.00930248p
Rt13 p7 tm11 0.00622931
Lt13 tm11 t12 0.837062n
Ct13 t12 0 0.155208p
Rt16 t12 tm14 0.00622931
Lt16 tm14 t15 0.837062n
Ct16 t15 0 0.155208p
Rt18 t15 tm17 0.00622931
Lt18 tm17 p10 0.837062n
Ct18 p10 0 0.155208p
Rt21 p10 tm20 0.000347492
Lt21 tm20 p19 0.0552252n
Ct21 p19 0 0.0131557p
Rt24 p19 tm23 0.00122857
Lt24 tm23 p22 0.195251n
Ct24 p22 0 0.0465124p
Rt27 p22 tm26 0.00420907
Lt27 tm26 p25 0.668926n
Ct27 p25 0 0.159351p
Rs31 p25 sm29 0.00455698
Ls31 sm29 s30 0.724217n
Cs31 s30 0 0.172522p
Rs34 s30 sm32 0.00455698
Ls34 sm32 s33 0.724217n
Cs34 s33 0 0.172522p
Rs37 s33 sm35 0.00455698
Ls37 sm35 s36 0.724217n
Cs37 s36 0 0.172522p
Rs40 s36 sm38 0.00455698
Ls40 sm38 s39 0.724217n
Cs40 s39 0 0.172522p
Rs43 s39 sm41 0.00455698
Ls43 sm41 s42 0.724217n
Cs43 s42 0 0.172522p
Rs46 s42 sm44 0.00455698
Ls46 sm44 s45 0.724217n
Cs46 s45 0 0.172522p
Rs49 s45 sm47 0.00455698
Ls49 sm47 s48 0.724217n
Cs49 s48 0 0.172522p
Rs52 s48 sm50 0.00455698
Ls52 sm50 s51 0.724217n
Cs52 s51 0 0.172522p
Rs55 s51 sm53 0.00455698
Ls55 sm53 s54 0.724217n
Cs55 s54 0 0.172522p
Rs58 s54 sm56 0.00455698
Ls58 sm56 s57 0.724217n
Cs58 s57 0 0.172522p
Rs61 s57 sm59 0.00455698
Ls61 sm59 s60 0.724217n
Cs61 s60 0 0.172522p
Rs63 s60 sm62 0.00455698
Ls63 sm62 stubend28 0.724217n
Cs63 stubend28 0 0.172522p
Cs64 stubend28 0 0.15p
Rt67 p25 tm66 8.44463e-06
Lt67 tm66 p65 0.00134206n
Ct67 p65 0 0.000319705p
Rt70 p65 tm69 0.0044698
Lt70 tm69 p68 0.710362n
Ct70 p68 0 0.169222p
Rt74 p68 tm72 0.00405429
Lt74 tm72 t73 0.644327n
Ct74 t73 0 0.153491p
Rt76 t73 tm75 0.00405429
Lt76 tm75 p71 0.644327n
Ct76 p71 0 0.153491p
Rt80 p71 tm78 0.00319429
Lt80 tm78 t79 0.507652n
Ct80 t79 0 0.120932p
Rt82 t79 tm81 0.00319429
Lt82 tm81 p77 0.507652n
Ct82 p77 0 0.120932p
Rt85 p77 tm84 0.00355924
Lt85 tm84 p83 0.565652n
Ct85 p83 0 0.134749p
Lv87 p83 v86 1.358n
Cv87 v86 0 0.4885p
Rt89 v86 tm88 0.00393119
Lt89 tm88 rs_a 0.624764n
Ct89 rs_a 0 0.148831p
Rser rs_a rs_b 100
Cser rs_b 0 0.1p
Rt92 rs_b tm91 0.001204
Lt92 tm91 p90 0.191346n
Ct92 p90 0 0.0455821p
Rs96 p90 sm94 0.00482214
Ls96 sm94 s95 0.766359n
Cs96 s95 0 0.182561p
Rs99 s95 sm97 0.00482214
Ls99 sm97 s98 0.766359n
Cs99 s98 0 0.182561p
Rs102 s98 sm100 0.00482214
Ls102 sm100 s101 0.766359n
Cs102 s101 0 0.182561p
Rs105 s101 sm103 0.00482214
Ls105 sm103 s104 0.766359n
Cs105 s104 0 0.182561p
Rs108 s104 sm106 0.00482214
Ls108 sm106 s107 0.766359n
Cs108 s107 0 0.182561p
Rs111 s107 sm109 0.00482214
Ls111 sm109 s110 0.766359n
Cs111 s110 0 0.182561p
Rs114 s110 sm112 0.00482214
Ls114 sm112 s113 0.766359n
Cs114 s113 0 0.182561p
Rs116 s113 sm115 0.00482214
Ls116 sm115 stubend93 0.766359n
Cs116 stubend93 0 0.182561p
Cs117 stubend93 0 0.15p
Rt120 p90 tm119 9.98773e-06
Lt120 tm119 p118 0.0015873n
Ct120 p118 0 0.000378125p
Rt123 p118 tm122 0.002752
Lt123 tm122 p121 0.500019n
Ct123 p121 0 0.144027p
Lv125 p121 v124 1.358n
Cv125 v124 0 0.4885p
Rt128 v124 tm126 0.00441003
Lt128 tm126 t127 0.700864n
Ct128 t127 0 0.166959p
Rt131 t127 tm129 0.00441003
Lt131 tm129 t130 0.700864n
Ct131 t130 0 0.166959p
Rt133 t130 tm132 0.00441003
Lt133 tm132 din 0.700864n
Ct133 din 0 0.166959p
Cin din 0 5p
.tran 0.1n 5000n 0 0.2n
.control
set wr_singlescale
set wr_vecnames
set numdgt=7
run

wrdata /out/led_hop15_nom.txt v(dout) v(din)
.endc
.end
