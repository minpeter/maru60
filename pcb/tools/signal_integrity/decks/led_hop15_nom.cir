* led_hop15_nom: SK6805 DOUT (assumed 100 ohm, 10 ns) -> 0.001 ohm in series -> routed hop -> DIN 5 pF
Vsrc src 0 PWL(0.0000n 0 100.0000n 0 110.0000n 4 400.0000n 4 410.0000n 0 1300.0000n 0 1310.0000n 4 2200.0000n 4 2210.0000n 0 2500.0000n 0 2510.0000n 4 2800.0000n 4 2810.0000n 0 3700.0000n 0 3710.0000n 4 4600.0000n 4 4610.0000n 0)
Rdrv src dout 100.0
Cdout dout 0 2p
Rt3 dout tm1 0.00382242
Lt3 tm1 t2 0.513637n
Ct3 t2 0 0.0952385p
Rt5 t2 tm4 0.00382242
Lt5 tm4 rs_a 0.513637n
Ct5 rs_a 0 0.0952385p
Rser rs_a rs_b 0.001
Cser rs_b 0 0.1p
Rt9 rs_b tm7 0.00572006
Lt9 tm7 t8 0.768633n
Ct9 t8 0 0.14252p
Rt12 t8 tm10 0.00572006
Lt12 tm10 t11 0.768633n
Ct12 t11 0 0.14252p
Rt15 t11 tm13 0.00572006
Lt15 tm13 t14 0.768633n
Ct15 t14 0 0.14252p
Rt18 t14 tm16 0.00572006
Lt18 tm16 t17 0.768633n
Ct18 t17 0 0.14252p
Rt21 t17 tm19 0.00572006
Lt21 tm19 t20 0.768633n
Ct21 t20 0 0.14252p
Rt24 t20 tm22 0.00572006
Lt24 tm22 t23 0.768633n
Ct24 t23 0 0.14252p
Rt26 t23 tm25 0.00572006
Lt26 tm25 p6 0.768633n
Ct26 p6 0 0.14252p
Lv28 p6 v27 1.358n
Cv28 v27 0 0.4885p
Rt31 v27 tm30 0.000108591
Lt31 tm30 p29 0.0226227n
Ct31 p29 0 0.00825347p
Rt35 p29 tm33 0.00636161
Lt35 tm33 t34 0.85484n
Ct35 t34 0 0.158504p
Rt38 t34 tm36 0.00636161
Lt38 tm36 t37 0.85484n
Ct38 t37 0 0.158504p
Rt41 t37 tm39 0.00636161
Lt41 tm39 t40 0.85484n
Ct41 t40 0 0.158504p
Rt44 t40 tm42 0.00636161
Lt44 tm42 t43 0.85484n
Ct44 t43 0 0.158504p
Rt47 t43 tm45 0.00636161
Lt47 tm45 t46 0.85484n
Ct47 t46 0 0.158504p
Rt50 t46 tm48 0.00636161
Lt50 tm48 t49 0.85484n
Ct50 t49 0 0.158504p
Rt53 t49 tm51 0.00636161
Lt53 tm51 t52 0.85484n
Ct53 t52 0 0.158504p
Rt56 t52 tm54 0.00636161
Lt56 tm54 t55 0.85484n
Ct56 t55 0 0.158504p
Rt59 t55 tm57 0.00636161
Lt59 tm57 t58 0.85484n
Ct59 t58 0 0.158504p
Rt62 t58 tm60 0.00636161
Lt62 tm60 t61 0.85484n
Ct62 t61 0 0.158504p
Rt65 t61 tm63 0.00636161
Lt65 tm63 t64 0.85484n
Ct65 t64 0 0.158504p
Rt68 t64 tm66 0.00636161
Lt68 tm66 t67 0.85484n
Ct68 t67 0 0.158504p
Rt71 t67 tm69 0.00636161
Lt71 tm69 t70 0.85484n
Ct71 t70 0 0.158504p
Rt74 t70 tm72 0.00636161
Lt74 tm72 t73 0.85484n
Ct74 t73 0 0.158504p
Rt77 t73 tm75 0.00636161
Lt77 tm75 t76 0.85484n
Ct77 t76 0 0.158504p
Rt80 t76 tm78 0.00636161
Lt80 tm78 t79 0.85484n
Ct80 t79 0 0.158504p
Rt83 t79 tm81 0.00636161
Lt83 tm81 t82 0.85484n
Ct83 t82 0 0.158504p
Rt86 t82 tm84 0.00636161
Lt86 tm84 t85 0.85484n
Ct86 t85 0 0.158504p
Rt89 t85 tm87 0.00636161
Lt89 tm87 t88 0.85484n
Ct89 t88 0 0.158504p
Rt92 t88 tm90 0.00636161
Lt92 tm90 t91 0.85484n
Ct92 t91 0 0.158504p
Rt95 t91 tm93 0.00636161
Lt95 tm93 t94 0.85484n
Ct95 t94 0 0.158504p
Rt98 t94 tm96 0.00636161
Lt98 tm96 t97 0.85484n
Ct98 t97 0 0.158504p
Rt101 t97 tm99 0.00636161
Lt101 tm99 t100 0.85484n
Ct101 t100 0 0.158504p
Rt103 t100 tm102 0.00636161
Lt103 tm102 p32 0.85484n
Ct103 p32 0 0.158504p
Lv105 p32 v104 1.358n
Cv105 v104 0 0.4885p
Rt108 v104 tm107 0.00447425
Lt108 tm107 p106 0.601226n
Ct108 p106 0 0.111479p
Lv110 p106 v109 1.358n
Cv110 v109 0 0.4885p
Rt114 v109 tm112 0.00642912
Lt114 tm112 t113 0.863912n
Ct114 t113 0 0.160187p
Rt117 t113 tm115 0.00642912
Lt117 tm115 t116 0.863912n
Ct117 t116 0 0.160187p
Rt120 t116 tm118 0.00642912
Lt120 tm118 t119 0.863912n
Ct120 t119 0 0.160187p
Rt123 t119 tm121 0.00642912
Lt123 tm121 t122 0.863912n
Ct123 t122 0 0.160187p
Rt126 t122 tm124 0.00642912
Lt126 tm124 t125 0.863912n
Ct126 t125 0 0.160187p
Rt129 t125 tm127 0.00642912
Lt129 tm127 t128 0.863912n
Ct129 t128 0 0.160187p
Rt132 t128 tm130 0.00642912
Lt132 tm130 t131 0.863912n
Ct132 t131 0 0.160187p
Rt135 t131 tm133 0.00642912
Lt135 tm133 t134 0.863912n
Ct135 t134 0 0.160187p
Rt138 t134 tm136 0.00642912
Lt138 tm136 t137 0.863912n
Ct138 t137 0 0.160187p
Rt141 t137 tm139 0.00642912
Lt141 tm139 t140 0.863912n
Ct141 t140 0 0.160187p
Rt144 t140 tm142 0.00642912
Lt144 tm142 t143 0.863912n
Ct144 t143 0 0.160187p
Rt146 t143 tm145 0.00642912
Lt146 tm145 p111 0.863912n
Ct146 p111 0 0.160187p
Lv148 p111 v147 1.358n
Cv148 v147 0 0.4885p
Rt151 v147 tm149 0.00595977
Lt151 tm149 t150 0.800844n
Ct151 t150 0 0.148492p
Rt154 t150 tm152 0.00595977
Lt154 tm152 t153 0.800844n
Ct154 t153 0 0.148492p
Rt157 t153 tm155 0.00595977
Lt157 tm155 t156 0.800844n
Ct157 t156 0 0.148492p
Rt160 t156 tm158 0.00595977
Lt160 tm158 t159 0.800844n
Ct160 t159 0 0.148492p
Rt163 t159 tm161 0.00595977
Lt163 tm161 t162 0.800844n
Ct163 t162 0 0.148492p
Rt166 t162 tm164 0.00595977
Lt166 tm164 t165 0.800844n
Ct166 t165 0 0.148492p
Rt169 t165 tm167 0.00595977
Lt169 tm167 t168 0.800844n
Ct169 t168 0 0.148492p
Rt172 t168 tm170 0.00595977
Lt172 tm170 t171 0.800844n
Ct172 t171 0 0.148492p
Rt175 t171 tm173 0.00595977
Lt175 tm173 t174 0.800844n
Ct175 t174 0 0.148492p
Rt177 t174 tm176 0.00595977
Lt177 tm176 din 0.800844n
Ct177 din 0 0.148492p
Cin din 0 5p
.tran 0.1n 5000n 0 0.2n
.control
set wr_singlescale
set wr_vecnames
set numdgt=7
run

wrdata /out/led_hop15_nom.txt v(dout) v(din)
.endc
.end
