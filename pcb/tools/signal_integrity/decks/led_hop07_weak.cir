* led_hop07_weak: SK6805 DOUT (assumed 500 ohm, 30 ns) -> routed hop -> DIN 5 pF
Vsrc src 0 PWL(0.0000n 0 100.0000n 0 130.0000n 4 400.0000n 4 430.0000n 0 1300.0000n 0 1330.0000n 4 2200.0000n 4 2230.0000n 0 2500.0000n 0 2530.0000n 4 2800.0000n 4 2830.0000n 0 3700.0000n 0 3730.0000n 4 4600.0000n 4 4630.0000n 0)
Rdrv src dout 500.0
Cdout dout 0 2p
Rt4 dout tm2 0.00361158
Lt4 tm2 t3 0.656199n
Ct4 t3 0 0.189013p
Rt7 t3 tm5 0.00361158
Lt7 tm5 t6 0.656199n
Ct7 t6 0 0.189013p
Rt10 t6 tm8 0.00361158
Lt10 tm8 t9 0.656199n
Ct10 t9 0 0.189013p
Rt13 t9 tm11 0.00361158
Lt13 tm11 t12 0.656199n
Ct13 t12 0 0.189013p
Rt16 t12 tm14 0.00361158
Lt16 tm14 t15 0.656199n
Ct16 t15 0 0.189013p
Rt19 t15 tm17 0.00361158
Lt19 tm17 t18 0.656199n
Ct19 t18 0 0.189013p
Rt22 t18 tm20 0.00361158
Lt22 tm20 t21 0.656199n
Ct22 t21 0 0.189013p
Rt25 t21 tm23 0.00361158
Lt25 tm23 t24 0.656199n
Ct25 t24 0 0.189013p
Rt28 t24 tm26 0.00361158
Lt28 tm26 t27 0.656199n
Ct28 t27 0 0.189013p
Rt31 t27 tm29 0.00361158
Lt31 tm29 t30 0.656199n
Ct31 t30 0 0.189013p
Rt34 t30 tm32 0.00361158
Lt34 tm32 t33 0.656199n
Ct34 t33 0 0.189013p
Rt36 t33 tm35 0.00361158
Lt36 tm35 p1 0.656199n
Ct36 p1 0 0.189013p
Rt39 p1 tm38 6.27234e-06
Lt39 tm38 p37 0.000996832n
Ct39 p37 0 0.000237464p
Rs43 p37 sm41 0.00430442
Ls43 sm41 s42 0.68408n
Cs43 s42 0 0.162961p
Rs46 s42 sm44 0.00430442
Ls46 sm44 s45 0.68408n
Cs46 s45 0 0.162961p
Rs49 s45 sm47 0.00430442
Ls49 sm47 s48 0.68408n
Cs49 s48 0 0.162961p
Rs52 s48 sm50 0.00430442
Ls52 sm50 s51 0.68408n
Cs52 s51 0 0.162961p
Rs54 s51 sm53 0.00430442
Ls54 sm53 stubend40 0.68408n
Cs54 stubend40 0 0.162961p
Cs55 stubend40 0 0.15p
Rt59 p37 tm57 0.00466857
Lt59 tm57 t58 0.741952n
Ct59 t58 0 0.176747p
Rt62 t58 tm60 0.00466857
Lt62 tm60 t61 0.741952n
Ct62 t61 0 0.176747p
Rt65 t61 tm63 0.00466857
Lt65 tm63 t64 0.741952n
Ct65 t64 0 0.176747p
Rt68 t64 tm66 0.00466857
Lt68 tm66 t67 0.741952n
Ct68 t67 0 0.176747p
Rt71 t67 tm69 0.00466857
Lt71 tm69 t70 0.741952n
Ct71 t70 0 0.176747p
Rt74 t70 tm72 0.00466857
Lt74 tm72 t73 0.741952n
Ct74 t73 0 0.176747p
Rt76 t73 tm75 0.00466857
Lt76 tm75 p56 0.741952n
Ct76 p56 0 0.176747p
Rs80 p56 sm78 0.00446381
Ls80 sm78 s79 0.709411n
Cs80 s79 0 0.168995p
Rs83 s79 sm81 0.00446381
Ls83 sm81 s82 0.709411n
Cs83 s82 0 0.168995p
Rs85 s82 sm84 0.00446381
Ls85 sm84 stubend77 0.709411n
Cs85 stubend77 0 0.168995p
Cs86 stubend77 0 0.15p
Rt89 p56 tm88 8.64979e-06
Lt89 tm88 p87 0.00137467n
Ct89 p87 0 0.000327472p
Lv91 p87 v90 1.358n
Cv91 v90 0 0.4885p
Rt94 v90 tm92 0.00373486
Lt94 tm92 t93 0.678597n
Ct94 t93 0 0.195465p
Rt97 t93 tm95 0.00373486
Lt97 tm95 t96 0.678597n
Ct97 t96 0 0.195465p
Rt100 t96 tm98 0.00373486
Lt100 tm98 t99 0.678597n
Ct100 t99 0 0.195465p
Rt103 t99 tm101 0.00373486
Lt103 tm101 t102 0.678597n
Ct103 t102 0 0.195465p
Rt106 t102 tm104 0.00373486
Lt106 tm104 t105 0.678597n
Ct106 t105 0 0.195465p
Rt109 t105 tm107 0.00373486
Lt109 tm107 t108 0.678597n
Ct109 t108 0 0.195465p
Rt112 t108 tm110 0.00373486
Lt112 tm110 t111 0.678597n
Ct112 t111 0 0.195465p
Rt115 t111 tm113 0.00373486
Lt115 tm113 t114 0.678597n
Ct115 t114 0 0.195465p
Rt117 t114 tm116 0.00373486
Lt117 tm116 din 0.678597n
Ct117 din 0 0.195465p
Cin din 0 5p
.tran 0.1n 5000n 0 0.2n
.control
set wr_singlescale
set wr_vecnames
set numdgt=7
run

wrdata /out/led_hop07_weak.txt v(dout) v(din)
.endc
.end
