* led_xtalk_2_victim_low_500: matrix line beside a quiet LED data hop, 32 mm at 0.2 mm gap
Vq q 0 0.0
Rq q v0 500.0
Vagg a 0 PWL(0 0 20n 0 21n 3.3 120n 3.3 121n 0)
Ragg a a0 40
Rt3 v0 tm1 0.00436143
Lt3 tm1 t2 0.69314n
Ct3 t2 0 0.165119p
Rt6 t2 tm4 0.00436143
Lt6 tm4 t5 0.69314n
Ct6 t5 0 0.165119p
Rt9 t5 tm7 0.00436143
Lt9 tm7 t8 0.69314n
Ct9 t8 0 0.165119p
Rt12 t8 tm10 0.00436143
Lt12 tm10 t11 0.69314n
Ct12 t11 0 0.165119p
Rt15 t11 tm13 0.00436143
Lt15 tm13 t14 0.69314n
Ct15 t14 0 0.165119p
Rt18 t14 tm16 0.00436143
Lt18 tm16 t17 0.69314n
Ct18 t17 0 0.165119p
Rt21 t17 tm19 0.00436143
Lt21 tm19 t20 0.69314n
Ct21 t20 0 0.165119p
Rt23 t20 tm22 0.00436143
Lt23 tm22 v1 0.69314n
Ct23 v1 0 0.165119p
Rca26 v1 cra27 0.00244179
Rcb26 a0 crb28 0.00244179
Lca26 cra27 ca24 0.383978n
Lcb26 crb28 cb25 0.383978n
Kc26 Lca26 Lcb26 0.23122
Cca26 ca24 0 0.0808023p
Ccb26 cb25 0 0.0808023p
Ccm26 ca24 cb25 0.0148047p
Rca31 ca24 cra32 0.00244179
Rcb31 cb25 crb33 0.00244179
Lca31 cra32 ca29 0.383978n
Lcb31 crb33 cb30 0.383978n
Kc31 Lca31 Lcb31 0.23122
Cca31 ca29 0 0.0808023p
Ccb31 cb30 0 0.0808023p
Ccm31 ca29 cb30 0.0148047p
Rca36 ca29 cra37 0.00244179
Rcb36 cb30 crb38 0.00244179
Lca36 cra37 ca34 0.383978n
Lcb36 crb38 cb35 0.383978n
Kc36 Lca36 Lcb36 0.23122
Cca36 ca34 0 0.0808023p
Ccb36 cb35 0 0.0808023p
Ccm36 ca34 cb35 0.0148047p
Rca41 ca34 cra42 0.00244179
Rcb41 cb35 crb43 0.00244179
Lca41 cra42 ca39 0.383978n
Lcb41 crb43 cb40 0.383978n
Kc41 Lca41 Lcb41 0.23122
Cca41 ca39 0 0.0808023p
Ccb41 cb40 0 0.0808023p
Ccm41 ca39 cb40 0.0148047p
Rca46 ca39 cra47 0.00244179
Rcb46 cb40 crb48 0.00244179
Lca46 cra47 ca44 0.383978n
Lcb46 crb48 cb45 0.383978n
Kc46 Lca46 Lcb46 0.23122
Cca46 ca44 0 0.0808023p
Ccb46 cb45 0 0.0808023p
Ccm46 ca44 cb45 0.0148047p
Rca51 ca44 cra52 0.00244179
Rcb51 cb45 crb53 0.00244179
Lca51 cra52 ca49 0.383978n
Lcb51 crb53 cb50 0.383978n
Kc51 Lca51 Lcb51 0.23122
Cca51 ca49 0 0.0808023p
Ccb51 cb50 0 0.0808023p
Ccm51 ca49 cb50 0.0148047p
Rca56 ca49 cra57 0.00244179
Rcb56 cb50 crb58 0.00244179
Lca56 cra57 ca54 0.383978n
Lcb56 crb58 cb55 0.383978n
Kc56 Lca56 Lcb56 0.23122
Cca56 ca54 0 0.0808023p
Ccb56 cb55 0 0.0808023p
Ccm56 ca54 cb55 0.0148047p
Rca61 ca54 cra62 0.00244179
Rcb61 cb55 crb63 0.00244179
Lca61 cra62 ca59 0.383978n
Lcb61 crb63 cb60 0.383978n
Kc61 Lca61 Lcb61 0.23122
Cca61 ca59 0 0.0808023p
Ccb61 cb60 0 0.0808023p
Ccm61 ca59 cb60 0.0148047p
Rca66 ca59 cra67 0.00244179
Rcb66 cb60 crb68 0.00244179
Lca66 cra67 ca64 0.383978n
Lcb66 crb68 cb65 0.383978n
Kc66 Lca66 Lcb66 0.23122
Cca66 ca64 0 0.0808023p
Ccb66 cb65 0 0.0808023p
Ccm66 ca64 cb65 0.0148047p
Rca71 ca64 cra72 0.00244179
Rcb71 cb65 crb73 0.00244179
Lca71 cra72 ca69 0.383978n
Lcb71 crb73 cb70 0.383978n
Kc71 Lca71 Lcb71 0.23122
Cca71 ca69 0 0.0808023p
Ccb71 cb70 0 0.0808023p
Ccm71 ca69 cb70 0.0148047p
Rca76 ca69 cra77 0.00244179
Rcb76 cb70 crb78 0.00244179
Lca76 cra77 ca74 0.383978n
Lcb76 crb78 cb75 0.383978n
Kc76 Lca76 Lcb76 0.23122
Cca76 ca74 0 0.0808023p
Ccb76 cb75 0 0.0808023p
Ccm76 ca74 cb75 0.0148047p
Rca81 ca74 cra82 0.00244179
Rcb81 cb75 crb83 0.00244179
Lca81 cra82 ca79 0.383978n
Lcb81 crb83 cb80 0.383978n
Kc81 Lca81 Lcb81 0.23122
Cca81 ca79 0 0.0808023p
Ccb81 cb80 0 0.0808023p
Ccm81 ca79 cb80 0.0148047p
Rca86 ca79 cra87 0.00244179
Rcb86 cb80 crb88 0.00244179
Lca86 cra87 ca84 0.383978n
Lcb86 crb88 cb85 0.383978n
Kc86 Lca86 Lcb86 0.23122
Cca86 ca84 0 0.0808023p
Ccb86 cb85 0 0.0808023p
Ccm86 ca84 cb85 0.0148047p
Rca91 ca84 cra92 0.00244179
Rcb91 cb85 crb93 0.00244179
Lca91 cra92 ca89 0.383978n
Lcb91 crb93 cb90 0.383978n
Kc91 Lca91 Lcb91 0.23122
Cca91 ca89 0 0.0808023p
Ccb91 cb90 0 0.0808023p
Ccm91 ca89 cb90 0.0148047p
Rca96 ca89 cra97 0.00244179
Rcb96 cb90 crb98 0.00244179
Lca96 cra97 ca94 0.383978n
Lcb96 crb98 cb95 0.383978n
Kc96 Lca96 Lcb96 0.23122
Cca96 ca94 0 0.0808023p
Ccb96 cb95 0 0.0808023p
Ccm96 ca94 cb95 0.0148047p
Rca101 ca94 cra102 0.00244179
Rcb101 cb95 crb103 0.00244179
Lca101 cra102 ca99 0.383978n
Lcb101 crb103 cb100 0.383978n
Kc101 Lca101 Lcb101 0.23122
Cca101 ca99 0 0.0808023p
Ccb101 cb100 0 0.0808023p
Ccm101 ca99 cb100 0.0148047p
Rca106 ca99 cra107 0.00244179
Rcb106 cb100 crb108 0.00244179
Lca106 cra107 ca104 0.383978n
Lcb106 crb108 cb105 0.383978n
Kc106 Lca106 Lcb106 0.23122
Cca106 ca104 0 0.0808023p
Ccb106 cb105 0 0.0808023p
Ccm106 ca104 cb105 0.0148047p
Rca111 ca104 cra112 0.00244179
Rcb111 cb105 crb113 0.00244179
Lca111 cra112 ca109 0.383978n
Lcb111 crb113 cb110 0.383978n
Kc111 Lca111 Lcb111 0.23122
Cca111 ca109 0 0.0808023p
Ccb111 cb110 0 0.0808023p
Ccm111 ca109 cb110 0.0148047p
Rca116 ca109 cra117 0.00244179
Rcb116 cb110 crb118 0.00244179
Lca116 cra117 ca114 0.383978n
Lcb116 crb118 cb115 0.383978n
Kc116 Lca116 Lcb116 0.23122
Cca116 ca114 0 0.0808023p
Ccb116 cb115 0 0.0808023p
Ccm116 ca114 cb115 0.0148047p
Rca121 ca114 cra122 0.00244179
Rcb121 cb115 crb123 0.00244179
Lca121 cra122 ca119 0.383978n
Lcb121 crb123 cb120 0.383978n
Kc121 Lca121 Lcb121 0.23122
Cca121 ca119 0 0.0808023p
Ccb121 cb120 0 0.0808023p
Ccm121 ca119 cb120 0.0148047p
Rca126 ca119 cra127 0.00244179
Rcb126 cb120 crb128 0.00244179
Lca126 cra127 ca124 0.383978n
Lcb126 crb128 cb125 0.383978n
Kc126 Lca126 Lcb126 0.23122
Cca126 ca124 0 0.0808023p
Ccb126 cb125 0 0.0808023p
Ccm126 ca124 cb125 0.0148047p
Rca131 ca124 cra132 0.00244179
Rcb131 cb125 crb133 0.00244179
Lca131 cra132 ca129 0.383978n
Lcb131 crb133 cb130 0.383978n
Kc131 Lca131 Lcb131 0.23122
Cca131 ca129 0 0.0808023p
Ccb131 cb130 0 0.0808023p
Ccm131 ca129 cb130 0.0148047p
Rca136 ca129 cra137 0.00244179
Rcb136 cb130 crb138 0.00244179
Lca136 cra137 ca134 0.383978n
Lcb136 crb138 cb135 0.383978n
Kc136 Lca136 Lcb136 0.23122
Cca136 ca134 0 0.0808023p
Ccb136 cb135 0 0.0808023p
Ccm136 ca134 cb135 0.0148047p
Rca141 ca134 cra142 0.00244179
Rcb141 cb135 crb143 0.00244179
Lca141 cra142 ca139 0.383978n
Lcb141 crb143 cb140 0.383978n
Kc141 Lca141 Lcb141 0.23122
Cca141 ca139 0 0.0808023p
Ccb141 cb140 0 0.0808023p
Ccm141 ca139 cb140 0.0148047p
Rca146 ca139 cra147 0.00244179
Rcb146 cb140 crb148 0.00244179
Lca146 cra147 ca144 0.383978n
Lcb146 crb148 cb145 0.383978n
Kc146 Lca146 Lcb146 0.23122
Cca146 ca144 0 0.0808023p
Ccb146 cb145 0 0.0808023p
Ccm146 ca144 cb145 0.0148047p
Rca151 ca144 cra152 0.00244179
Rcb151 cb145 crb153 0.00244179
Lca151 cra152 ca149 0.383978n
Lcb151 crb153 cb150 0.383978n
Kc151 Lca151 Lcb151 0.23122
Cca151 ca149 0 0.0808023p
Ccb151 cb150 0 0.0808023p
Ccm151 ca149 cb150 0.0148047p
Rca156 ca149 cra157 0.00244179
Rcb156 cb150 crb158 0.00244179
Lca156 cra157 ca154 0.383978n
Lcb156 crb158 cb155 0.383978n
Kc156 Lca156 Lcb156 0.23122
Cca156 ca154 0 0.0808023p
Ccb156 cb155 0 0.0808023p
Ccm156 ca154 cb155 0.0148047p
Rca161 ca154 cra162 0.00244179
Rcb161 cb155 crb163 0.00244179
Lca161 cra162 ca159 0.383978n
Lcb161 crb163 cb160 0.383978n
Kc161 Lca161 Lcb161 0.23122
Cca161 ca159 0 0.0808023p
Ccb161 cb160 0 0.0808023p
Ccm161 ca159 cb160 0.0148047p
Rca166 ca159 cra167 0.00244179
Rcb166 cb160 crb168 0.00244179
Lca166 cra167 ca164 0.383978n
Lcb166 crb168 cb165 0.383978n
Kc166 Lca166 Lcb166 0.23122
Cca166 ca164 0 0.0808023p
Ccb166 cb165 0 0.0808023p
Ccm166 ca164 cb165 0.0148047p
Rca171 ca164 cra172 0.00244179
Rcb171 cb165 crb173 0.00244179
Lca171 cra172 ca169 0.383978n
Lcb171 crb173 cb170 0.383978n
Kc171 Lca171 Lcb171 0.23122
Cca171 ca169 0 0.0808023p
Ccb171 cb170 0 0.0808023p
Ccm171 ca169 cb170 0.0148047p
Rca176 ca169 cra177 0.00244179
Rcb176 cb170 crb178 0.00244179
Lca176 cra177 ca174 0.383978n
Lcb176 crb178 cb175 0.383978n
Kc176 Lca176 Lcb176 0.23122
Cca176 ca174 0 0.0808023p
Ccb176 cb175 0 0.0808023p
Ccm176 ca174 cb175 0.0148047p
Rca179 ca174 cra180 0.00244179
Rcb179 cb175 crb181 0.00244179
Lca179 cra180 v2 0.383978n
Lcb179 crb181 a1 0.383978n
Kc179 Lca179 Lcb179 0.23122
Cca179 v2 0 0.0808023p
Ccb179 a1 0 0.0808023p
Ccm179 v2 a1 0.0148047p
Rt184 v2 tm182 0.00436143
Lt184 tm182 t183 0.69314n
Ct184 t183 0 0.165119p
Rt187 t183 tm185 0.00436143
Lt187 tm185 t186 0.69314n
Ct187 t186 0 0.165119p
Rt190 t186 tm188 0.00436143
Lt190 tm188 t189 0.69314n
Ct190 t189 0 0.165119p
Rt193 t189 tm191 0.00436143
Lt193 tm191 t192 0.69314n
Ct193 t192 0 0.165119p
Rt196 t192 tm194 0.00436143
Lt196 tm194 t195 0.69314n
Ct196 t195 0 0.165119p
Rt199 t195 tm197 0.00436143
Lt199 tm197 t198 0.69314n
Ct199 t198 0 0.165119p
Rt202 t198 tm200 0.00436143
Lt202 tm200 t201 0.69314n
Ct202 t201 0 0.165119p
Rt204 t201 tm203 0.00436143
Lt204 tm203 din 0.69314n
Ct204 din 0 0.165119p
Cin din 0 5p
Cagg a1 0 30p
.options method=gear reltol=1e-3
.tran 0.05n 220n 0 0.1n
.control
set wr_singlescale
set wr_vecnames
set numdgt=7
run

wrdata /out/led_xtalk_2_victim_low_500.txt v(din) v(a1) v(v1)
.endc
.end
