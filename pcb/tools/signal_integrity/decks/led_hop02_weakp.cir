* led_hop02_weakp: SK6805 DOUT (assumed 1000 ohm, 30 ns) -> routed hop -> DIN 15 pF
Vsrc src 0 PWL(0.0000n 0 100.0000n 0 130.0000n 4 400.0000n 4 430.0000n 0 1300.0000n 0 1330.0000n 4 2200.0000n 4 2230.0000n 0 2500.0000n 0 2530.0000n 4 2800.0000n 4 2830.0000n 0 3700.0000n 0 3730.0000n 4 4600.0000n 4 4630.0000n 0)
Rdrv src dout 1000.0
Cdout dout 0 2p
Rt4 dout tm2 0.00342362
Lt4 tm2 t3 0.460048n
Ct4 t3 0 0.0853021p
Rt6 t3 tm5 0.00342362
Lt6 tm5 p1 0.460048n
Ct6 p1 0 0.0853021p
Lv8 p1 v7 1.358n
Cv8 v7 0 0.4885p
Rt12 v7 tm10 0.00530976
Lt12 tm10 t11 0.713498n
Ct12 t11 0 0.132297p
Rt14 t11 tm13 0.00530976
Lt14 tm13 p9 0.713498n
Ct14 p9 0 0.132297p
Lv16 p9 v15 1.358n
Cv16 v15 0 0.4885p
Rt20 v15 tm18 0.00654447
Lt20 tm18 t19 0.879411n
Ct20 t19 0 0.16306p
Rt23 t19 tm21 0.00654447
Lt23 tm21 t22 0.879411n
Ct23 t22 0 0.16306p
Rt26 t22 tm24 0.00654447
Lt26 tm24 t25 0.879411n
Ct26 t25 0 0.16306p
Rt29 t25 tm27 0.00654447
Lt29 tm27 t28 0.879411n
Ct29 t28 0 0.16306p
Rt32 t28 tm30 0.00654447
Lt32 tm30 t31 0.879411n
Ct32 t31 0 0.16306p
Rt35 t31 tm33 0.00654447
Lt35 tm33 t34 0.879411n
Ct35 t34 0 0.16306p
Rt38 t34 tm36 0.00654447
Lt38 tm36 t37 0.879411n
Ct38 t37 0 0.16306p
Rt41 t37 tm39 0.00654447
Lt41 tm39 t40 0.879411n
Ct41 t40 0 0.16306p
Rt44 t40 tm42 0.00654447
Lt44 tm42 t43 0.879411n
Ct44 t43 0 0.16306p
Rt47 t43 tm45 0.00654447
Lt47 tm45 t46 0.879411n
Ct47 t46 0 0.16306p
Rt50 t46 tm48 0.00654447
Lt50 tm48 t49 0.879411n
Ct50 t49 0 0.16306p
Rt53 t49 tm51 0.00654447
Lt53 tm51 t52 0.879411n
Ct53 t52 0 0.16306p
Rt56 t52 tm54 0.00654447
Lt56 tm54 t55 0.879411n
Ct56 t55 0 0.16306p
Rt59 t55 tm57 0.00654447
Lt59 tm57 t58 0.879411n
Ct59 t58 0 0.16306p
Rt62 t58 tm60 0.00654447
Lt62 tm60 t61 0.879411n
Ct62 t61 0 0.16306p
Rt65 t61 tm63 0.00654447
Lt65 tm63 t64 0.879411n
Ct65 t64 0 0.16306p
Rt68 t64 tm66 0.00654447
Lt68 tm66 t67 0.879411n
Ct68 t67 0 0.16306p
Rt71 t67 tm69 0.00654447
Lt71 tm69 t70 0.879411n
Ct71 t70 0 0.16306p
Rt74 t70 tm72 0.00654447
Lt74 tm72 t73 0.879411n
Ct74 t73 0 0.16306p
Rt77 t73 tm75 0.00654447
Lt77 tm75 t76 0.879411n
Ct77 t76 0 0.16306p
Rt80 t76 tm78 0.00654447
Lt80 tm78 t79 0.879411n
Ct80 t79 0 0.16306p
Rt83 t79 tm81 0.00654447
Lt83 tm81 t82 0.879411n
Ct83 t82 0 0.16306p
Rt86 t82 tm84 0.00654447
Lt86 tm84 t85 0.879411n
Ct86 t85 0 0.16306p
Rt89 t85 tm87 0.00654447
Lt89 tm87 t88 0.879411n
Ct89 t88 0 0.16306p
Rt92 t88 tm90 0.00654447
Lt92 tm90 t91 0.879411n
Ct92 t91 0 0.16306p
Rt95 t91 tm93 0.00654447
Lt95 tm93 t94 0.879411n
Ct95 t94 0 0.16306p
Rt98 t94 tm96 0.00654447
Lt98 tm96 t97 0.879411n
Ct98 t97 0 0.16306p
Rt101 t97 tm99 0.00654447
Lt101 tm99 t100 0.879411n
Ct101 t100 0 0.16306p
Rt104 t100 tm102 0.00654447
Lt104 tm102 t103 0.879411n
Ct104 t103 0 0.16306p
Rt107 t103 tm105 0.00654447
Lt107 tm105 t106 0.879411n
Ct107 t106 0 0.16306p
Rt110 t106 tm108 0.00654447
Lt110 tm108 t109 0.879411n
Ct110 t109 0 0.16306p
Rt113 t109 tm111 0.00654447
Lt113 tm111 t112 0.879411n
Ct113 t112 0 0.16306p
Rt116 t112 tm114 0.00654447
Lt116 tm114 t115 0.879411n
Ct116 t115 0 0.16306p
Rt119 t115 tm117 0.00654447
Lt119 tm117 t118 0.879411n
Ct119 t118 0 0.16306p
Rt121 t118 tm120 0.00654447
Lt121 tm120 p17 0.879411n
Ct121 p17 0 0.16306p
Lv123 p17 v122 1.358n
Cv123 v122 0 0.4885p
Rt127 v122 tm125 0.00622476
Lt127 tm125 t126 0.836451n
Ct127 t126 0 0.155095p
Rt130 t126 tm128 0.00622476
Lt130 tm128 t129 0.836451n
Ct130 t129 0 0.155095p
Rt132 t129 tm131 0.00622476
Lt132 tm131 p124 0.836451n
Ct132 p124 0 0.155095p
Lv134 p124 v133 1.358n
Cv134 v133 0 0.4885p
Rt136 v133 tm135 0.0016381
Lt136 tm135 din 0.220119n
Ct136 din 0 0.0408144p
Cin din 0 15p
.tran 0.1n 5000n 0 0.2n
.control
set wr_singlescale
set wr_vecnames
set numdgt=7
run

wrdata /out/led_hop02_weakp.txt v(dout) v(din)
.endc
.end
