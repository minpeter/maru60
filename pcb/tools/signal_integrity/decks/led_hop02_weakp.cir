* led_hop02_weakp: SK6805 DOUT (assumed 1000 ohm, 30 ns) -> 100 ohm in series -> routed hop -> DIN 15 pF
Vsrc src 0 PWL(0.0000n 0 100.0000n 0 130.0000n 4 400.0000n 4 430.0000n 0 1300.0000n 0 1330.0000n 4 2200.0000n 4 2230.0000n 0 2500.0000n 0 2530.0000n 4 2800.0000n 4 2830.0000n 0 3700.0000n 0 3730.0000n 4 4600.0000n 4 4630.0000n 0)
Rdrv src dout 1000.0
Cdout dout 0 2p
Rt4 dout tm2 0.00342362
Lt4 tm2 t3 0.460048n
Ct4 t3 0 0.0853021p
Rt6 t3 tm5 0.00342362
Lt6 tm5 p1 0.460048n
Ct6 p1 0 0.0853021p
Lv8 p1 v7 1.358n
Cv8 v7 0 0.4885p
Rt10 v7 tm9 0.0028127
Lt10 tm9 rs_a 0.377956n
Ct10 rs_a 0 0.0700807p
Rser rs_a rs_b 100
Cser rs_b 0 0.1p
Rt14 rs_b tm12 0.00451873
Lt14 tm12 t13 0.607204n
Ct14 t13 0 0.112588p
Rt16 t13 tm15 0.00451873
Lt16 tm15 p11 0.607204n
Ct16 p11 0 0.112588p
Lv18 p11 v17 1.358n
Cv18 v17 0 0.4885p
Rt22 v17 tm20 0.00654447
Lt22 tm20 t21 0.879411n
Ct22 t21 0 0.16306p
Rt25 t21 tm23 0.00654447
Lt25 tm23 t24 0.879411n
Ct25 t24 0 0.16306p
Rt28 t24 tm26 0.00654447
Lt28 tm26 t27 0.879411n
Ct28 t27 0 0.16306p
Rt31 t27 tm29 0.00654447
Lt31 tm29 t30 0.879411n
Ct31 t30 0 0.16306p
Rt34 t30 tm32 0.00654447
Lt34 tm32 t33 0.879411n
Ct34 t33 0 0.16306p
Rt37 t33 tm35 0.00654447
Lt37 tm35 t36 0.879411n
Ct37 t36 0 0.16306p
Rt40 t36 tm38 0.00654447
Lt40 tm38 t39 0.879411n
Ct40 t39 0 0.16306p
Rt43 t39 tm41 0.00654447
Lt43 tm41 t42 0.879411n
Ct43 t42 0 0.16306p
Rt46 t42 tm44 0.00654447
Lt46 tm44 t45 0.879411n
Ct46 t45 0 0.16306p
Rt49 t45 tm47 0.00654447
Lt49 tm47 t48 0.879411n
Ct49 t48 0 0.16306p
Rt52 t48 tm50 0.00654447
Lt52 tm50 t51 0.879411n
Ct52 t51 0 0.16306p
Rt55 t51 tm53 0.00654447
Lt55 tm53 t54 0.879411n
Ct55 t54 0 0.16306p
Rt58 t54 tm56 0.00654447
Lt58 tm56 t57 0.879411n
Ct58 t57 0 0.16306p
Rt61 t57 tm59 0.00654447
Lt61 tm59 t60 0.879411n
Ct61 t60 0 0.16306p
Rt64 t60 tm62 0.00654447
Lt64 tm62 t63 0.879411n
Ct64 t63 0 0.16306p
Rt67 t63 tm65 0.00654447
Lt67 tm65 t66 0.879411n
Ct67 t66 0 0.16306p
Rt70 t66 tm68 0.00654447
Lt70 tm68 t69 0.879411n
Ct70 t69 0 0.16306p
Rt73 t69 tm71 0.00654447
Lt73 tm71 t72 0.879411n
Ct73 t72 0 0.16306p
Rt76 t72 tm74 0.00654447
Lt76 tm74 t75 0.879411n
Ct76 t75 0 0.16306p
Rt79 t75 tm77 0.00654447
Lt79 tm77 t78 0.879411n
Ct79 t78 0 0.16306p
Rt82 t78 tm80 0.00654447
Lt82 tm80 t81 0.879411n
Ct82 t81 0 0.16306p
Rt85 t81 tm83 0.00654447
Lt85 tm83 t84 0.879411n
Ct85 t84 0 0.16306p
Rt88 t84 tm86 0.00654447
Lt88 tm86 t87 0.879411n
Ct88 t87 0 0.16306p
Rt91 t87 tm89 0.00654447
Lt91 tm89 t90 0.879411n
Ct91 t90 0 0.16306p
Rt94 t90 tm92 0.00654447
Lt94 tm92 t93 0.879411n
Ct94 t93 0 0.16306p
Rt97 t93 tm95 0.00654447
Lt97 tm95 t96 0.879411n
Ct97 t96 0 0.16306p
Rt100 t96 tm98 0.00654447
Lt100 tm98 t99 0.879411n
Ct100 t99 0 0.16306p
Rt103 t99 tm101 0.00654447
Lt103 tm101 t102 0.879411n
Ct103 t102 0 0.16306p
Rt106 t102 tm104 0.00654447
Lt106 tm104 t105 0.879411n
Ct106 t105 0 0.16306p
Rt109 t105 tm107 0.00654447
Lt109 tm107 t108 0.879411n
Ct109 t108 0 0.16306p
Rt112 t108 tm110 0.00654447
Lt112 tm110 t111 0.879411n
Ct112 t111 0 0.16306p
Rt115 t111 tm113 0.00654447
Lt115 tm113 t114 0.879411n
Ct115 t114 0 0.16306p
Rt118 t114 tm116 0.00654447
Lt118 tm116 t117 0.879411n
Ct118 t117 0 0.16306p
Rt121 t117 tm119 0.00654447
Lt121 tm119 t120 0.879411n
Ct121 t120 0 0.16306p
Rt123 t120 tm122 0.00654447
Lt123 tm122 p19 0.879411n
Ct123 p19 0 0.16306p
Lv125 p19 v124 1.358n
Cv125 v124 0 0.4885p
Rt129 v124 tm127 0.00622476
Lt129 tm127 t128 0.836451n
Ct129 t128 0 0.155095p
Rt132 t128 tm130 0.00622476
Lt132 tm130 t131 0.836451n
Ct132 t131 0 0.155095p
Rt134 t131 tm133 0.00622476
Lt134 tm133 p126 0.836451n
Ct134 p126 0 0.155095p
Lv136 p126 v135 1.358n
Cv136 v135 0 0.4885p
Rt138 v135 tm137 0.0016381
Lt138 tm137 din 0.220119n
Ct138 din 0 0.0408144p
Cin din 0 15p
.tran 0.1n 5000n 0 0.2n
.control
set wr_singlescale
set wr_vecnames
set numdgt=7
run

wrdata /out/led_hop02_weakp.txt v(dout) v(din)
.endc
.end
