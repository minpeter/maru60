* led_hop22_nom: SK6805 DOUT (assumed 100 ohm, 10 ns) -> 100 ohm in series -> routed hop -> DIN 5 pF
Vsrc src 0 PWL(0.0000n 0 100.0000n 0 110.0000n 4 400.0000n 4 410.0000n 0 1300.0000n 0 1310.0000n 4 2200.0000n 4 2210.0000n 0 2500.0000n 0 2510.0000n 4 2800.0000n 4 2810.0000n 0 3700.0000n 0 3710.0000n 4 4600.0000n 4 4610.0000n 0)
Rdrv src dout 100.0
Cdout dout 0 2p
Rt3 dout tm2 0.00434366
Lt3 tm2 p1 0.690315n
Ct3 p1 0 0.164446p
Rt6 p1 tm5 0.000122857
Lt6 tm5 p4 0.0195251n
Ct6 p4 0 0.00465124p
Rt10 p4 tm8 0.00425678
Lt10 tm8 t9 0.676509n
Ct10 t9 0 0.161157p
Rt12 t9 tm11 0.00425678
Lt12 tm11 p7 0.676509n
Ct12 p7 0 0.161157p
Rt16 p7 tm14 0.00364867
Lt16 tm14 t15 0.579865n
Ct16 t15 0 0.138135p
Rt18 t15 tm17 0.00364867
Lt18 tm17 p13 0.579865n
Ct18 p13 0 0.138135p
Rt22 p13 tm20 0.00260619
Lt22 tm20 t21 0.414189n
Ct22 t21 0 0.0986677p
Rt24 t21 tm23 0.00260619
Lt24 tm23 p19 0.414189n
Ct24 p19 0 0.0986677p
Rt27 p19 tm25 0.00277994
Lt27 tm25 t26 0.441802n
Ct27 t26 0 0.105246p
Rt29 t26 tm28 0.00277994
Lt29 tm28 rs_a 0.441802n
Ct29 rs_a 0 0.105246p
Rser rs_a rs_b 100
Cser rs_b 0 0.1p
Rt32 rs_b tm31 0.00382242
Lt32 tm31 p30 0.607477n
Ct32 p30 0 0.144713p
Rt35 p30 tm34 0.000122857
Lt35 tm34 p33 0.0195251n
Ct35 p33 0 0.00465124p
Rt39 p33 tm37 0.00304056
Lt39 tm37 t38 0.483221n
Ct39 t38 0 0.115112p
Rt41 t38 tm40 0.00304056
Lt41 tm40 p36 0.483221n
Ct41 p36 0 0.115112p
Rt44 p36 tm42 0.00449118
Lt44 tm42 t43 0.71376n
Ct44 t43 0 0.170031p
Rt47 t43 tm45 0.00449118
Lt47 tm45 t46 0.71376n
Ct47 t46 0 0.170031p
Rt50 t46 tm48 0.00449118
Lt50 tm48 t49 0.71376n
Ct50 t49 0 0.170031p
Rt53 t49 tm51 0.00449118
Lt53 tm51 t52 0.71376n
Ct53 t52 0 0.170031p
Rt56 t52 tm54 0.00449118
Lt56 tm54 t55 0.71376n
Ct56 t55 0 0.170031p
Rt59 t55 tm57 0.00449118
Lt59 tm57 t58 0.71376n
Ct59 t58 0 0.170031p
Rt62 t58 tm60 0.00449118
Lt62 tm60 t61 0.71376n
Ct62 t61 0 0.170031p
Rt65 t61 tm63 0.00449118
Lt65 tm63 t64 0.71376n
Ct65 t64 0 0.170031p
Rt68 t64 tm66 0.00449118
Lt68 tm66 t67 0.71376n
Ct68 t67 0 0.170031p
Rt70 t67 tm69 0.00449118
Lt70 tm69 din 0.71376n
Ct70 din 0 0.170031p
Cin din 0 5p
.tran 0.1n 5000n 0 0.2n
.control
set wr_singlescale
set wr_vecnames
set numdgt=7
run

wrdata /out/led_hop22_nom.txt v(dout) v(din)
.endc
.end
