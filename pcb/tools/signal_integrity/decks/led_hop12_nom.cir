* led_hop12_nom: SK6805 DOUT (assumed 100 ohm, 10 ns) -> routed hop -> DIN 5 pF
Vsrc src 0 PWL(0.0000n 0 100.0000n 0 110.0000n 4 400.0000n 4 410.0000n 0 1300.0000n 0 1310.0000n 4 2200.0000n 4 2210.0000n 0 2500.0000n 0 2510.0000n 4 2800.0000n 4 2810.0000n 0 3700.0000n 0 3710.0000n 4 4600.0000n 4 4610.0000n 0)
Rdrv src dout 100.0
Cdout dout 0 2p
Rt4 dout tm2 0.00319429
Lt4 tm2 t3 0.507652n
Ct4 t3 0 0.120932p
Rt6 t3 tm5 0.00319429
Lt6 tm5 p1 0.507652n
Ct6 p1 0 0.120932p
Rs10 p1 sm8 0.0043688
Ls10 sm8 s9 0.694311n
Cs10 s9 0 0.165398p
Rs13 s9 sm11 0.0043688
Ls13 sm11 s12 0.694311n
Cs13 s12 0 0.165398p
Rs16 s12 sm14 0.0043688
Ls16 sm14 s15 0.694311n
Cs16 s15 0 0.165398p
Rs19 s15 sm17 0.0043688
Ls19 sm17 s18 0.694311n
Cs19 s18 0 0.165398p
Rs22 s18 sm20 0.0043688
Ls22 sm20 s21 0.694311n
Cs22 s21 0 0.165398p
Rs25 s21 sm23 0.0043688
Ls25 sm23 s24 0.694311n
Cs25 s24 0 0.165398p
Rs27 s24 sm26 0.0043688
Ls27 sm26 stubend7 0.694311n
Cs27 stubend7 0 0.165398p
Cs28 stubend7 0 0.4885p
Cs29 stubend7 0 0.15p
Rt32 p1 tm30 0.00491332
Lt32 tm30 t31 0.780849n
Ct32 t31 0 0.186013p
Rt35 t31 tm33 0.00491332
Lt35 tm33 t34 0.780849n
Ct35 t34 0 0.186013p
Rt38 t34 tm36 0.00491332
Lt38 tm36 t37 0.780849n
Ct38 t37 0 0.186013p
Rt41 t37 tm39 0.00491332
Lt41 tm39 t40 0.780849n
Ct41 t40 0 0.186013p
Rt44 t40 tm42 0.00491332
Lt44 tm42 t43 0.780849n
Ct44 t43 0 0.186013p
Rt47 t43 tm45 0.00491332
Lt47 tm45 t46 0.780849n
Ct47 t46 0 0.186013p
Rt50 t46 tm48 0.00491332
Lt50 tm48 t49 0.780849n
Ct50 t49 0 0.186013p
Rt53 t49 tm51 0.00491332
Lt53 tm51 t52 0.780849n
Ct53 t52 0 0.186013p
Rt56 t52 tm54 0.00491332
Lt56 tm54 t55 0.780849n
Ct56 t55 0 0.186013p
Rt59 t55 tm57 0.00491332
Lt59 tm57 t58 0.780849n
Ct59 t58 0 0.186013p
Rt62 t58 tm60 0.00491332
Lt62 tm60 t61 0.780849n
Ct62 t61 0 0.186013p
Rt65 t61 tm63 0.00491332
Lt65 tm63 t64 0.780849n
Ct65 t64 0 0.186013p
Rt68 t64 tm66 0.00491332
Lt68 tm66 t67 0.780849n
Ct68 t67 0 0.186013p
Rt71 t67 tm69 0.00491332
Lt71 tm69 t70 0.780849n
Ct71 t70 0 0.186013p
Rt73 t70 tm72 0.00491332
Lt73 tm72 din 0.780849n
Ct73 din 0 0.186013p
Cin din 0 5p
.tran 0.1n 5000n 0 0.2n
.control
set wr_singlescale
set wr_vecnames
set numdgt=7
run

wrdata /out/led_hop12_nom.txt v(dout) v(din)
.endc
.end
