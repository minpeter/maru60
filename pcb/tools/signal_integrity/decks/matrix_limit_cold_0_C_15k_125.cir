* matrix: 15 key(s) of the same row closed, RON 125 ohm, RPU 86 k, 0 C
.options temp=0 method=gear
Vdd vdd 0 3.3
.model D4148 D(IS=2.52n RS=0.568 N=1.752 CJO=0.9p M=0.4 VJ=0.7 TT=4n BV=100 IBV=1u)
.model SWROW SW(RON=1 ROFF=1G VT=0.5 VH=0.01)
Vsel sel 0 PWL(0 0 100n 0 101.5n 1 2000n 1 2001.5n 0)
Srow rowpin rdrv sel 0 SWROW
Rron rdrv 0 124
Rpur vdd rowpin 86000.0
Cpinr rowpin 0 5.0p
Rr0 rowpin rw1x 0.066568
Lr0 rw1x rw1 10.579n
Cr0 rw1 0 5.7917p
Rr1 rw1 rw2x 0.066568
Lr1 rw2x rw2 10.579n
Cr1 rw2 0 5.7917p
Rr2 rw2 rw3x 0.066568
Lr2 rw3x rw3 10.579n
Cr2 rw3 0 5.7917p
Rr3 rw3 rw4x 0.066568
Lr3 rw4x rw4 10.579n
Cr3 rw4 0 5.7917p
Rr4 rw4 rw5x 0.066568
Lr4 rw5x rw5 10.579n
Cr4 rw5 0 5.7917p
Rr5 rw5 rw6x 0.066568
Lr5 rw6x rw6 10.579n
Cr5 rw6 0 5.7917p
Rr6 rw6 rw7x 0.066568
Lr6 rw7x rw7 10.579n
Cr6 rw7 0 5.7917p
Rr7 rw7 rw8x 0.066568
Lr7 rw8x rw8 10.579n
Cr7 rw8 0 5.7917p
Rr8 rw8 rw9x 0.066568
Lr8 rw9x rw9 10.579n
Cr8 rw9 0 5.7917p
Rr9 rw9 rw10x 0.066568
Lr9 rw10x rw10 10.579n
Cr9 rw10 0 5.7917p
Rr10 rw10 rw11x 0.066568
Lr10 rw11x rw11 10.579n
Cr10 rw11 0 5.7917p
Rr11 rw11 rowfarx 0.066568
Lr11 rowfarx rowfar 10.579n
Cr11 rowfar 0 5.7917p
D0 key0 rowfar D4148
Ckey0 key0 0 8.8p
Rsw0 key0 colfar0 0.2
Rpuc0 vdd colpin0 86000.0
Cpinc0 colpin0 0 5.0p
Rc0_0 colfar0 c0_0x 0.052583
Lc0_0 c0_0x c0_0 8.3567n
Cc0_0 c0_0 0 3.6733p
Rc0_1 c0_0 c0_1x 0.052583
Lc0_1 c0_1x c0_1 8.3567n
Cc0_1 c0_1 0 3.6733p
Rc0_2 c0_1 c0_2x 0.052583
Lc0_2 c0_2x c0_2 8.3567n
Cc0_2 c0_2 0 3.6733p
Rc0_3 c0_2 c0_3x 0.052583
Lc0_3 c0_3x c0_3 8.3567n
Cc0_3 c0_3 0 3.6733p
Rc0_4 c0_3 c0_4x 0.052583
Lc0_4 c0_4x c0_4 8.3567n
Cc0_4 c0_4 0 3.6733p
Rc0_5 c0_4 c0_5x 0.052583
Lc0_5 c0_5x c0_5 8.3567n
Cc0_5 c0_5 0 3.6733p
Rc0_6 c0_5 c0_6x 0.052583
Lc0_6 c0_6x c0_6 8.3567n
Cc0_6 c0_6 0 3.6733p
Rc0_7 c0_6 c0_7x 0.052583
Lc0_7 c0_7x c0_7 8.3567n
Cc0_7 c0_7 0 3.6733p
Rc0_8 c0_7 c0_8x 0.052583
Lc0_8 c0_8x c0_8 8.3567n
Cc0_8 c0_8 0 3.6733p
Rc0_9 c0_8 c0_9x 0.052583
Lc0_9 c0_9x c0_9 8.3567n
Cc0_9 c0_9 0 3.6733p
Rc0_10 c0_9 c0_10x 0.052583
Lc0_10 c0_10x c0_10 8.3567n
Cc0_10 c0_10 0 3.6733p
Rc0_11 c0_10 colpin0x 0.052583
Lc0_11 colpin0x colpin0 8.3567n
Cc0_11 colpin0 0 3.6733p
D1 key1 rw4 D4148
Ckey1 key1 0 8.8p
Rsw1 key1 colfar1 0.2
Rpuc1 vdd colpin1 86000.0
Cpinc1 colpin1 0 5.0p
Rc1_0 colfar1 c1_0x 0.056862
Lc1_0 c1_0x c1_0 9.0369n
Cc1_0 c1_0 0 3.4092p
Rc1_1 c1_0 c1_1x 0.056862
Lc1_1 c1_1x c1_1 9.0369n
Cc1_1 c1_1 0 3.4092p
Rc1_2 c1_1 c1_2x 0.056862
Lc1_2 c1_2x c1_2 9.0369n
Cc1_2 c1_2 0 3.4092p
Rc1_3 c1_2 c1_3x 0.056862
Lc1_3 c1_3x c1_3 9.0369n
Cc1_3 c1_3 0 3.4092p
Rc1_4 c1_3 c1_4x 0.056862
Lc1_4 c1_4x c1_4 9.0369n
Cc1_4 c1_4 0 3.4092p
Rc1_5 c1_4 c1_5x 0.056862
Lc1_5 c1_5x c1_5 9.0369n
Cc1_5 c1_5 0 3.4092p
Rc1_6 c1_5 c1_6x 0.056862
Lc1_6 c1_6x c1_6 9.0369n
Cc1_6 c1_6 0 3.4092p
Rc1_7 c1_6 c1_7x 0.056862
Lc1_7 c1_7x c1_7 9.0369n
Cc1_7 c1_7 0 3.4092p
Rc1_8 c1_7 c1_8x 0.056862
Lc1_8 c1_8x c1_8 9.0369n
Cc1_8 c1_8 0 3.4092p
Rc1_9 c1_8 c1_9x 0.056862
Lc1_9 c1_9x c1_9 9.0369n
Cc1_9 c1_9 0 3.4092p
Rc1_10 c1_9 c1_10x 0.056862
Lc1_10 c1_10x c1_10 9.0369n
Cc1_10 c1_10 0 3.4092p
Rc1_11 c1_10 colpin1x 0.056862
Lc1_11 colpin1x colpin1 9.0369n
Cc1_11 colpin1 0 3.4092p
D2 key2 rw7 D4148
Ckey2 key2 0 8.8p
Rsw2 key2 colfar2 0.2
Rpuc2 vdd colpin2 86000.0
Cpinc2 colpin2 0 5.0p
Rc2_0 colfar2 c2_0x 0.045969
Lc2_0 c2_0x c2_0 7.3056n
Cc2_0 c2_0 0 2.8508p
Rc2_1 c2_0 c2_1x 0.045969
Lc2_1 c2_1x c2_1 7.3056n
Cc2_1 c2_1 0 2.8508p
Rc2_2 c2_1 c2_2x 0.045969
Lc2_2 c2_2x c2_2 7.3056n
Cc2_2 c2_2 0 2.8508p
Rc2_3 c2_2 c2_3x 0.045969
Lc2_3 c2_3x c2_3 7.3056n
Cc2_3 c2_3 0 2.8508p
Rc2_4 c2_3 c2_4x 0.045969
Lc2_4 c2_4x c2_4 7.3056n
Cc2_4 c2_4 0 2.8508p
Rc2_5 c2_4 c2_5x 0.045969
Lc2_5 c2_5x c2_5 7.3056n
Cc2_5 c2_5 0 2.8508p
Rc2_6 c2_5 c2_6x 0.045969
Lc2_6 c2_6x c2_6 7.3056n
Cc2_6 c2_6 0 2.8508p
Rc2_7 c2_6 c2_7x 0.045969
Lc2_7 c2_7x c2_7 7.3056n
Cc2_7 c2_7 0 2.8508p
Rc2_8 c2_7 c2_8x 0.045969
Lc2_8 c2_8x c2_8 7.3056n
Cc2_8 c2_8 0 2.8508p
Rc2_9 c2_8 c2_9x 0.045969
Lc2_9 c2_9x c2_9 7.3056n
Cc2_9 c2_9 0 2.8508p
Rc2_10 c2_9 c2_10x 0.045969
Lc2_10 c2_10x c2_10 7.3056n
Cc2_10 c2_10 0 2.8508p
Rc2_11 c2_10 colpin2x 0.045969
Lc2_11 colpin2x colpin2 7.3056n
Cc2_11 colpin2 0 2.8508p
D3 key3 rw10 D4148
Ckey3 key3 0 8.8p
Rsw3 key3 colfar3 0.2
Rpuc3 vdd colpin3 86000.0
Cpinc3 colpin3 0 5.0p
Rc3_0 colfar3 c3_0x 0.02967
Lc3_0 c3_0x c3_0 4.7153n
Cc3_0 c3_0 0 2.8167p
Rc3_1 c3_0 c3_1x 0.02967
Lc3_1 c3_1x c3_1 4.7153n
Cc3_1 c3_1 0 2.8167p
Rc3_2 c3_1 c3_2x 0.02967
Lc3_2 c3_2x c3_2 4.7153n
Cc3_2 c3_2 0 2.8167p
Rc3_3 c3_2 c3_3x 0.02967
Lc3_3 c3_3x c3_3 4.7153n
Cc3_3 c3_3 0 2.8167p
Rc3_4 c3_3 c3_4x 0.02967
Lc3_4 c3_4x c3_4 4.7153n
Cc3_4 c3_4 0 2.8167p
Rc3_5 c3_4 c3_5x 0.02967
Lc3_5 c3_5x c3_5 4.7153n
Cc3_5 c3_5 0 2.8167p
Rc3_6 c3_5 c3_6x 0.02967
Lc3_6 c3_6x c3_6 4.7153n
Cc3_6 c3_6 0 2.8167p
Rc3_7 c3_6 c3_7x 0.02967
Lc3_7 c3_7x c3_7 4.7153n
Cc3_7 c3_7 0 2.8167p
Rc3_8 c3_7 c3_8x 0.02967
Lc3_8 c3_8x c3_8 4.7153n
Cc3_8 c3_8 0 2.8167p
Rc3_9 c3_8 c3_9x 0.02967
Lc3_9 c3_9x c3_9 4.7153n
Cc3_9 c3_9 0 2.8167p
Rc3_10 c3_9 c3_10x 0.02967
Lc3_10 c3_10x c3_10 4.7153n
Cc3_10 c3_10 0 2.8167p
Rc3_11 c3_10 colpin3x 0.02967
Lc3_11 colpin3x colpin3 4.7153n
Cc3_11 colpin3 0 2.8167p
D4 key4 rw2 D4148
Ckey4 key4 0 8.8p
Rsw4 key4 colfar4 0.2
Rpuc4 vdd colpin4 86000.0
Cpinc4 colpin4 0 5.0p
Rc4_0 colfar4 c4_0x 0.056228
Lc4_0 c4_0x c4_0 8.936n
Cc4_0 c4_0 0 2.6642p
Rc4_1 c4_0 c4_1x 0.056228
Lc4_1 c4_1x c4_1 8.936n
Cc4_1 c4_1 0 2.6642p
Rc4_2 c4_1 c4_2x 0.056228
Lc4_2 c4_2x c4_2 8.936n
Cc4_2 c4_2 0 2.6642p
Rc4_3 c4_2 c4_3x 0.056228
Lc4_3 c4_3x c4_3 8.936n
Cc4_3 c4_3 0 2.6642p
Rc4_4 c4_3 c4_4x 0.056228
Lc4_4 c4_4x c4_4 8.936n
Cc4_4 c4_4 0 2.6642p
Rc4_5 c4_4 c4_5x 0.056228
Lc4_5 c4_5x c4_5 8.936n
Cc4_5 c4_5 0 2.6642p
Rc4_6 c4_5 c4_6x 0.056228
Lc4_6 c4_6x c4_6 8.936n
Cc4_6 c4_6 0 2.6642p
Rc4_7 c4_6 c4_7x 0.056228
Lc4_7 c4_7x c4_7 8.936n
Cc4_7 c4_7 0 2.6642p
Rc4_8 c4_7 c4_8x 0.056228
Lc4_8 c4_8x c4_8 8.936n
Cc4_8 c4_8 0 2.6642p
Rc4_9 c4_8 c4_9x 0.056228
Lc4_9 c4_9x c4_9 8.936n
Cc4_9 c4_9 0 2.6642p
Rc4_10 c4_9 c4_10x 0.056228
Lc4_10 c4_10x c4_10 8.936n
Cc4_10 c4_10 0 2.6642p
Rc4_11 c4_10 colpin4x 0.056228
Lc4_11 colpin4x colpin4 8.936n
Cc4_11 colpin4 0 2.6642p
D5 key5 rw5 D4148
Ckey5 key5 0 8.8p
Rsw5 key5 colfar5 0.2
Rpuc5 vdd colpin5 86000.0
Cpinc5 colpin5 0 5.0p
Rc5_0 colfar5 c5_0x 0.043266
Lc5_0 c5_0x c5_0 6.8761n
Cc5_0 c5_0 0 2.6108p
Rc5_1 c5_0 c5_1x 0.043266
Lc5_1 c5_1x c5_1 6.8761n
Cc5_1 c5_1 0 2.6108p
Rc5_2 c5_1 c5_2x 0.043266
Lc5_2 c5_2x c5_2 6.8761n
Cc5_2 c5_2 0 2.6108p
Rc5_3 c5_2 c5_3x 0.043266
Lc5_3 c5_3x c5_3 6.8761n
Cc5_3 c5_3 0 2.6108p
Rc5_4 c5_3 c5_4x 0.043266
Lc5_4 c5_4x c5_4 6.8761n
Cc5_4 c5_4 0 2.6108p
Rc5_5 c5_4 c5_5x 0.043266
Lc5_5 c5_5x c5_5 6.8761n
Cc5_5 c5_5 0 2.6108p
Rc5_6 c5_5 c5_6x 0.043266
Lc5_6 c5_6x c5_6 6.8761n
Cc5_6 c5_6 0 2.6108p
Rc5_7 c5_6 c5_7x 0.043266
Lc5_7 c5_7x c5_7 6.8761n
Cc5_7 c5_7 0 2.6108p
Rc5_8 c5_7 c5_8x 0.043266
Lc5_8 c5_8x c5_8 6.8761n
Cc5_8 c5_8 0 2.6108p
Rc5_9 c5_8 c5_9x 0.043266
Lc5_9 c5_9x c5_9 6.8761n
Cc5_9 c5_9 0 2.6108p
Rc5_10 c5_9 c5_10x 0.043266
Lc5_10 c5_10x c5_10 6.8761n
Cc5_10 c5_10 0 2.6108p
Rc5_11 c5_10 colpin5x 0.043266
Lc5_11 colpin5x colpin5 6.8761n
Cc5_11 colpin5 0 2.6108p
D6 key6 rw8 D4148
Ckey6 key6 0 8.8p
Rsw6 key6 colfar6 0.2
Rpuc6 vdd colpin6 86000.0
Cpinc6 colpin6 0 5.0p
Rc6_0 colfar6 c6_0x 0.035178
Lc6_0 c6_0x c6_0 5.5907n
Cc6_0 c6_0 0 2.4533p
Rc6_1 c6_0 c6_1x 0.035178
Lc6_1 c6_1x c6_1 5.5907n
Cc6_1 c6_1 0 2.4533p
Rc6_2 c6_1 c6_2x 0.035178
Lc6_2 c6_2x c6_2 5.5907n
Cc6_2 c6_2 0 2.4533p
Rc6_3 c6_2 c6_3x 0.035178
Lc6_3 c6_3x c6_3 5.5907n
Cc6_3 c6_3 0 2.4533p
Rc6_4 c6_3 c6_4x 0.035178
Lc6_4 c6_4x c6_4 5.5907n
Cc6_4 c6_4 0 2.4533p
Rc6_5 c6_4 c6_5x 0.035178
Lc6_5 c6_5x c6_5 5.5907n
Cc6_5 c6_5 0 2.4533p
Rc6_6 c6_5 c6_6x 0.035178
Lc6_6 c6_6x c6_6 5.5907n
Cc6_6 c6_6 0 2.4533p
Rc6_7 c6_6 c6_7x 0.035178
Lc6_7 c6_7x c6_7 5.5907n
Cc6_7 c6_7 0 2.4533p
Rc6_8 c6_7 c6_8x 0.035178
Lc6_8 c6_8x c6_8 5.5907n
Cc6_8 c6_8 0 2.4533p
Rc6_9 c6_8 c6_9x 0.035178
Lc6_9 c6_9x c6_9 5.5907n
Cc6_9 c6_9 0 2.4533p
Rc6_10 c6_9 c6_10x 0.035178
Lc6_10 c6_10x c6_10 5.5907n
Cc6_10 c6_10 0 2.4533p
Rc6_11 c6_10 colpin6x 0.035178
Lc6_11 colpin6x colpin6 5.5907n
Cc6_11 colpin6 0 2.4533p
D7 key7 rw11 D4148
Ckey7 key7 0 8.8p
Rsw7 key7 colfar7 0.2
Rpuc7 vdd colpin7 86000.0
Cpinc7 colpin7 0 5.0p
Rc7_0 colfar7 c7_0x 0.053607
Lc7_0 c7_0x c7_0 8.5194n
Cc7_0 c7_0 0 2.3225p
Rc7_1 c7_0 c7_1x 0.053607
Lc7_1 c7_1x c7_1 8.5194n
Cc7_1 c7_1 0 2.3225p
Rc7_2 c7_1 c7_2x 0.053607
Lc7_2 c7_2x c7_2 8.5194n
Cc7_2 c7_2 0 2.3225p
Rc7_3 c7_2 c7_3x 0.053607
Lc7_3 c7_3x c7_3 8.5194n
Cc7_3 c7_3 0 2.3225p
Rc7_4 c7_3 c7_4x 0.053607
Lc7_4 c7_4x c7_4 8.5194n
Cc7_4 c7_4 0 2.3225p
Rc7_5 c7_4 c7_5x 0.053607
Lc7_5 c7_5x c7_5 8.5194n
Cc7_5 c7_5 0 2.3225p
Rc7_6 c7_5 c7_6x 0.053607
Lc7_6 c7_6x c7_6 8.5194n
Cc7_6 c7_6 0 2.3225p
Rc7_7 c7_6 c7_7x 0.053607
Lc7_7 c7_7x c7_7 8.5194n
Cc7_7 c7_7 0 2.3225p
Rc7_8 c7_7 c7_8x 0.053607
Lc7_8 c7_8x c7_8 8.5194n
Cc7_8 c7_8 0 2.3225p
Rc7_9 c7_8 c7_9x 0.053607
Lc7_9 c7_9x c7_9 8.5194n
Cc7_9 c7_9 0 2.3225p
Rc7_10 c7_9 c7_10x 0.053607
Lc7_10 c7_10x c7_10 8.5194n
Cc7_10 c7_10 0 2.3225p
Rc7_11 c7_10 colpin7x 0.053607
Lc7_11 colpin7x colpin7 8.5194n
Cc7_11 colpin7 0 2.3225p
D8 key8 rw3 D4148
Ckey8 key8 0 8.8p
Rsw8 key8 colfar8 0.2
Rpuc8 vdd colpin8 86000.0
Cpinc8 colpin8 0 5.0p
Rc8_0 colfar8 c8_0x 0.030776
Lc8_0 c8_0x c8_0 4.891n
Cc8_0 c8_0 0 2.2983p
Rc8_1 c8_0 c8_1x 0.030776
Lc8_1 c8_1x c8_1 4.891n
Cc8_1 c8_1 0 2.2983p
Rc8_2 c8_1 c8_2x 0.030776
Lc8_2 c8_2x c8_2 4.891n
Cc8_2 c8_2 0 2.2983p
Rc8_3 c8_2 c8_3x 0.030776
Lc8_3 c8_3x c8_3 4.891n
Cc8_3 c8_3 0 2.2983p
Rc8_4 c8_3 c8_4x 0.030776
Lc8_4 c8_4x c8_4 4.891n
Cc8_4 c8_4 0 2.2983p
Rc8_5 c8_4 c8_5x 0.030776
Lc8_5 c8_5x c8_5 4.891n
Cc8_5 c8_5 0 2.2983p
Rc8_6 c8_5 c8_6x 0.030776
Lc8_6 c8_6x c8_6 4.891n
Cc8_6 c8_6 0 2.2983p
Rc8_7 c8_6 c8_7x 0.030776
Lc8_7 c8_7x c8_7 4.891n
Cc8_7 c8_7 0 2.2983p
Rc8_8 c8_7 c8_8x 0.030776
Lc8_8 c8_8x c8_8 4.891n
Cc8_8 c8_8 0 2.2983p
Rc8_9 c8_8 c8_9x 0.030776
Lc8_9 c8_9x c8_9 4.891n
Cc8_9 c8_9 0 2.2983p
Rc8_10 c8_9 c8_10x 0.030776
Lc8_10 c8_10x c8_10 4.891n
Cc8_10 c8_10 0 2.2983p
Rc8_11 c8_10 colpin8x 0.030776
Lc8_11 colpin8x colpin8 4.891n
Cc8_11 colpin8 0 2.2983p
D9 key9 rw6 D4148
Ckey9 key9 0 8.8p
Rsw9 key9 colfar9 0.2
Rpuc9 vdd colpin9 86000.0
Cpinc9 colpin9 0 5.0p
Rc9_0 colfar9 c9_0x 0.032741
Lc9_0 c9_0x c9_0 5.2034n
Cc9_0 c9_0 0 2.1667p
Rc9_1 c9_0 c9_1x 0.032741
Lc9_1 c9_1x c9_1 5.2034n
Cc9_1 c9_1 0 2.1667p
Rc9_2 c9_1 c9_2x 0.032741
Lc9_2 c9_2x c9_2 5.2034n
Cc9_2 c9_2 0 2.1667p
Rc9_3 c9_2 c9_3x 0.032741
Lc9_3 c9_3x c9_3 5.2034n
Cc9_3 c9_3 0 2.1667p
Rc9_4 c9_3 c9_4x 0.032741
Lc9_4 c9_4x c9_4 5.2034n
Cc9_4 c9_4 0 2.1667p
Rc9_5 c9_4 c9_5x 0.032741
Lc9_5 c9_5x c9_5 5.2034n
Cc9_5 c9_5 0 2.1667p
Rc9_6 c9_5 c9_6x 0.032741
Lc9_6 c9_6x c9_6 5.2034n
Cc9_6 c9_6 0 2.1667p
Rc9_7 c9_6 c9_7x 0.032741
Lc9_7 c9_7x c9_7 5.2034n
Cc9_7 c9_7 0 2.1667p
Rc9_8 c9_7 c9_8x 0.032741
Lc9_8 c9_8x c9_8 5.2034n
Cc9_8 c9_8 0 2.1667p
Rc9_9 c9_8 c9_9x 0.032741
Lc9_9 c9_9x c9_9 5.2034n
Cc9_9 c9_9 0 2.1667p
Rc9_10 c9_9 c9_10x 0.032741
Lc9_10 c9_10x c9_10 5.2034n
Cc9_10 c9_10 0 2.1667p
Rc9_11 c9_10 colpin9x 0.032741
Lc9_11 colpin9x colpin9 5.2034n
Cc9_11 colpin9 0 2.1667p
D10 key10 rw9 D4148
Ckey10 key10 0 8.8p
Rsw10 key10 colfar10 0.2
Rpuc10 vdd colpin10 86000.0
Cpinc10 colpin10 0 5.0p
Rc10_0 colfar10 c10_0x 0.028482
Lc10_0 c10_0x c10_0 4.5266n
Cc10_0 c10_0 0 2.0267p
Rc10_1 c10_0 c10_1x 0.028482
Lc10_1 c10_1x c10_1 4.5266n
Cc10_1 c10_1 0 2.0267p
Rc10_2 c10_1 c10_2x 0.028482
Lc10_2 c10_2x c10_2 4.5266n
Cc10_2 c10_2 0 2.0267p
Rc10_3 c10_2 c10_3x 0.028482
Lc10_3 c10_3x c10_3 4.5266n
Cc10_3 c10_3 0 2.0267p
Rc10_4 c10_3 c10_4x 0.028482
Lc10_4 c10_4x c10_4 4.5266n
Cc10_4 c10_4 0 2.0267p
Rc10_5 c10_4 c10_5x 0.028482
Lc10_5 c10_5x c10_5 4.5266n
Cc10_5 c10_5 0 2.0267p
Rc10_6 c10_5 c10_6x 0.028482
Lc10_6 c10_6x c10_6 4.5266n
Cc10_6 c10_6 0 2.0267p
Rc10_7 c10_6 c10_7x 0.028482
Lc10_7 c10_7x c10_7 4.5266n
Cc10_7 c10_7 0 2.0267p
Rc10_8 c10_7 c10_8x 0.028482
Lc10_8 c10_8x c10_8 4.5266n
Cc10_8 c10_8 0 2.0267p
Rc10_9 c10_8 c10_9x 0.028482
Lc10_9 c10_9x c10_9 4.5266n
Cc10_9 c10_9 0 2.0267p
Rc10_10 c10_9 c10_10x 0.028482
Lc10_10 c10_10x c10_10 4.5266n
Cc10_10 c10_10 0 2.0267p
Rc10_11 c10_10 colpin10x 0.028482
Lc10_11 colpin10x colpin10 4.5266n
Cc10_11 colpin10 0 2.0267p
D11 key11 rw1 D4148
Ckey11 key11 0 8.8p
Rsw11 key11 colfar11 0.2
Rpuc11 vdd colpin11 86000.0
Cpinc11 colpin11 0 5.0p
Rc11_0 colfar11 c11_0x 0.025902
Lc11_0 c11_0x c11_0 4.1165n
Cc11_0 c11_0 0 1.9517p
Rc11_1 c11_0 c11_1x 0.025902
Lc11_1 c11_1x c11_1 4.1165n
Cc11_1 c11_1 0 1.9517p
Rc11_2 c11_1 c11_2x 0.025902
Lc11_2 c11_2x c11_2 4.1165n
Cc11_2 c11_2 0 1.9517p
Rc11_3 c11_2 c11_3x 0.025902
Lc11_3 c11_3x c11_3 4.1165n
Cc11_3 c11_3 0 1.9517p
Rc11_4 c11_3 c11_4x 0.025902
Lc11_4 c11_4x c11_4 4.1165n
Cc11_4 c11_4 0 1.9517p
Rc11_5 c11_4 c11_5x 0.025902
Lc11_5 c11_5x c11_5 4.1165n
Cc11_5 c11_5 0 1.9517p
Rc11_6 c11_5 c11_6x 0.025902
Lc11_6 c11_6x c11_6 4.1165n
Cc11_6 c11_6 0 1.9517p
Rc11_7 c11_6 c11_7x 0.025902
Lc11_7 c11_7x c11_7 4.1165n
Cc11_7 c11_7 0 1.9517p
Rc11_8 c11_7 c11_8x 0.025902
Lc11_8 c11_8x c11_8 4.1165n
Cc11_8 c11_8 0 1.9517p
Rc11_9 c11_8 c11_9x 0.025902
Lc11_9 c11_9x c11_9 4.1165n
Cc11_9 c11_9 0 1.9517p
Rc11_10 c11_9 c11_10x 0.025902
Lc11_10 c11_10x c11_10 4.1165n
Cc11_10 c11_10 0 1.9517p
Rc11_11 c11_10 colpin11x 0.025902
Lc11_11 colpin11x colpin11 4.1165n
Cc11_11 colpin11 0 1.9517p
D12 key12 rw4 D4148
Ckey12 key12 0 8.8p
Rsw12 key12 colfar12 0.2
Rpuc12 vdd colpin12 86000.0
Cpinc12 colpin12 0 5.0p
Rc12_0 colfar12 c12_0x 0.028585
Lc12_0 c12_0x c12_0 4.5428n
Cc12_0 c12_0 0 1.9192p
Rc12_1 c12_0 c12_1x 0.028585
Lc12_1 c12_1x c12_1 4.5428n
Cc12_1 c12_1 0 1.9192p
Rc12_2 c12_1 c12_2x 0.028585
Lc12_2 c12_2x c12_2 4.5428n
Cc12_2 c12_2 0 1.9192p
Rc12_3 c12_2 c12_3x 0.028585
Lc12_3 c12_3x c12_3 4.5428n
Cc12_3 c12_3 0 1.9192p
Rc12_4 c12_3 c12_4x 0.028585
Lc12_4 c12_4x c12_4 4.5428n
Cc12_4 c12_4 0 1.9192p
Rc12_5 c12_4 c12_5x 0.028585
Lc12_5 c12_5x c12_5 4.5428n
Cc12_5 c12_5 0 1.9192p
Rc12_6 c12_5 c12_6x 0.028585
Lc12_6 c12_6x c12_6 4.5428n
Cc12_6 c12_6 0 1.9192p
Rc12_7 c12_6 c12_7x 0.028585
Lc12_7 c12_7x c12_7 4.5428n
Cc12_7 c12_7 0 1.9192p
Rc12_8 c12_7 c12_8x 0.028585
Lc12_8 c12_8x c12_8 4.5428n
Cc12_8 c12_8 0 1.9192p
Rc12_9 c12_8 c12_9x 0.028585
Lc12_9 c12_9x c12_9 4.5428n
Cc12_9 c12_9 0 1.9192p
Rc12_10 c12_9 c12_10x 0.028585
Lc12_10 c12_10x c12_10 4.5428n
Cc12_10 c12_10 0 1.9192p
Rc12_11 c12_10 colpin12x 0.028585
Lc12_11 colpin12x colpin12 4.5428n
Cc12_11 colpin12 0 1.9192p
D13 key13 rw7 D4148
Ckey13 key13 0 8.8p
Rsw13 key13 colfar13 0.2
Rpuc13 vdd colpin13 86000.0
Cpinc13 colpin13 0 5.0p
Rc13_0 colfar13 c13_0x 0.0080881
Lc13_0 c13_0x c13_0 1.2854n
Cc13_0 c13_0 0 1.6925p
Rc13_1 c13_0 c13_1x 0.0080881
Lc13_1 c13_1x c13_1 1.2854n
Cc13_1 c13_1 0 1.6925p
Rc13_2 c13_1 c13_2x 0.0080881
Lc13_2 c13_2x c13_2 1.2854n
Cc13_2 c13_2 0 1.6925p
Rc13_3 c13_2 c13_3x 0.0080881
Lc13_3 c13_3x c13_3 1.2854n
Cc13_3 c13_3 0 1.6925p
Rc13_4 c13_3 c13_4x 0.0080881
Lc13_4 c13_4x c13_4 1.2854n
Cc13_4 c13_4 0 1.6925p
Rc13_5 c13_4 c13_5x 0.0080881
Lc13_5 c13_5x c13_5 1.2854n
Cc13_5 c13_5 0 1.6925p
Rc13_6 c13_5 c13_6x 0.0080881
Lc13_6 c13_6x c13_6 1.2854n
Cc13_6 c13_6 0 1.6925p
Rc13_7 c13_6 c13_7x 0.0080881
Lc13_7 c13_7x c13_7 1.2854n
Cc13_7 c13_7 0 1.6925p
Rc13_8 c13_7 c13_8x 0.0080881
Lc13_8 c13_8x c13_8 1.2854n
Cc13_8 c13_8 0 1.6925p
Rc13_9 c13_8 c13_9x 0.0080881
Lc13_9 c13_9x c13_9 1.2854n
Cc13_9 c13_9 0 1.6925p
Rc13_10 c13_9 c13_10x 0.0080881
Lc13_10 c13_10x c13_10 1.2854n
Cc13_10 c13_10 0 1.6925p
Rc13_11 c13_10 colpin13x 0.0080881
Lc13_11 colpin13x colpin13 1.2854n
Cc13_11 colpin13 0 1.6925p
D14 key14 rw10 D4148
Ckey14 key14 0 8.8p
Rsw14 key14 colfar14 0.2
Rpuc14 vdd colpin14 86000.0
Cpinc14 colpin14 0 5.0p
Rc14_0 colfar14 c14_0x 0.017261
Lc14_0 c14_0x c14_0 2.7433n
Cc14_0 c14_0 0 1.2233p
Rc14_1 c14_0 c14_1x 0.017261
Lc14_1 c14_1x c14_1 2.7433n
Cc14_1 c14_1 0 1.2233p
Rc14_2 c14_1 c14_2x 0.017261
Lc14_2 c14_2x c14_2 2.7433n
Cc14_2 c14_2 0 1.2233p
Rc14_3 c14_2 c14_3x 0.017261
Lc14_3 c14_3x c14_3 2.7433n
Cc14_3 c14_3 0 1.2233p
Rc14_4 c14_3 c14_4x 0.017261
Lc14_4 c14_4x c14_4 2.7433n
Cc14_4 c14_4 0 1.2233p
Rc14_5 c14_4 c14_5x 0.017261
Lc14_5 c14_5x c14_5 2.7433n
Cc14_5 c14_5 0 1.2233p
Rc14_6 c14_5 c14_6x 0.017261
Lc14_6 c14_6x c14_6 2.7433n
Cc14_6 c14_6 0 1.2233p
Rc14_7 c14_6 c14_7x 0.017261
Lc14_7 c14_7x c14_7 2.7433n
Cc14_7 c14_7 0 1.2233p
Rc14_8 c14_7 c14_8x 0.017261
Lc14_8 c14_8x c14_8 2.7433n
Cc14_8 c14_8 0 1.2233p
Rc14_9 c14_8 c14_9x 0.017261
Lc14_9 c14_9x c14_9 2.7433n
Cc14_9 c14_9 0 1.2233p
Rc14_10 c14_9 c14_10x 0.017261
Lc14_10 c14_10x c14_10 2.7433n
Cc14_10 c14_10 0 1.2233p
Rc14_11 c14_10 colpin14x 0.017261
Lc14_11 colpin14x colpin14 2.7433n
Cc14_11 colpin14 0 1.2233p
.tran 0.2n 40u 0 20n
.control
set wr_singlescale
set wr_vecnames
set numdgt=7
run

wrdata /out/matrix_limit_cold_0_C_15k_125.txt v(rowpin) v(rowfar) v(colpin0) v(sel)
.endc
.end
