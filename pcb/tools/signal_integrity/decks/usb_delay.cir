* USB: propagation delay from the J1 pads to the RP2350 pins (one differential edge, matched ends)
Vp sp 0 PWL(0 0 2n 0 3n 3.3)
Vm sm 0 PWL(0 3.3 2n 3.3 3n 0)
Rsp sp conp 45
Rsm sm conm 45
Rtp pinp 0 20
Rtm pinm 0 20
Rt3 pinp tm1 0.0026891
Lt3 tm1 t2 0.361347n
Ct3 t2 0 0.067001p
Rt6 t2 tm4 0.0026891
Lt6 tm4 t5 0.361347n
Ct6 t5 0 0.067001p
Rt9 t5 tm7 0.0026891
Lt9 tm7 t8 0.361347n
Ct9 t8 0 0.067001p
Rt12 t8 tm10 0.0026891
Lt12 tm10 t11 0.361347n
Ct12 t11 0 0.067001p
Rt14 t11 tm13 0.0026891
Lt14 tm13 rp_a 0.361347n
Ct14 rp_a 0 0.067001p
Rt17 pinm tm15 0.00312876
Lt17 tm15 t16 0.420427n
Ct17 t16 0 0.0779556p
Rt20 t16 tm18 0.00312876
Lt20 tm18 t19 0.420427n
Ct20 t19 0 0.0779556p
Rt23 t19 tm21 0.00312876
Lt23 tm21 t22 0.420427n
Ct23 t22 0 0.0779556p
Rt25 t22 tm24 0.00312876
Lt25 tm24 rm_a 0.420427n
Ct25 rm_a 0 0.0779556p
R102 rp_a rp_b 27
R103 rm_a rm_b 27
Rt30 conp tm29 0.0030141
Lt30 tm29 u28 0.405019n
Ct30 u28 0 0.0750985p
Lv32 u28 u31 1.358n
Cv32 u31 0 0.4885p
Rt35 u31 tm33 0.0058536
Lt35 tm33 t34 0.786577n
Ct35 t34 0 0.145847p
Rt38 t34 tm36 0.0058536
Lt38 tm36 t37 0.786577n
Ct38 t37 0 0.145847p
Rt41 t37 tm39 0.0058536
Lt41 tm39 t40 0.786577n
Ct41 t40 0 0.145847p
Rt43 t40 tm42 0.0058536
Lt43 tm42 dp26 0.786577n
Ct43 dp26 0 0.145847p
Rt47 conm tm45 0.00596219
Lt47 tm45 t46 0.801168n
Ct47 t46 0 0.148553p
Rt50 t46 tm48 0.00596219
Lt50 tm48 t49 0.801168n
Ct50 t49 0 0.148553p
Rt52 t49 tm51 0.00596219
Lt52 tm51 u44 0.801168n
Ct52 u44 0 0.148553p
Lv54 u44 u53 1.358n
Cv54 u53 0 0.4885p
Rt57 u53 tm55 0.00520452
Lt57 tm55 t56 0.699357n
Ct57 t56 0 0.129675p
Rt60 t56 tm58 0.00520452
Lt60 tm58 t59 0.699357n
Ct60 t59 0 0.129675p
Rt62 t59 tm61 0.00520452
Lt62 tm61 dm27 0.699357n
Ct62 dm27 0 0.129675p
Rp1a69 dp26 p1ra70 0.00558854
Rp1b69 dm27 p1rb71 0.00558854
Lp1a69 p1ra70 p1a67 1.00306n
Lp1b69 p1rb71 p1b68 1.00306n
Kp169 Lp1a69 Lp1b69 0.22195
Cp1a69 p1a67 0 0.25838p
Cp1b69 p1b68 0 0.25838p
Cp1m69 p1a67 p1b68 0.0433125p
Rp1a74 p1a67 p1ra75 0.00558854
Rp1b74 p1b68 p1rb76 0.00558854
Lp1a74 p1ra75 p1a72 1.00306n
Lp1b74 p1rb76 p1b73 1.00306n
Kp174 Lp1a74 Lp1b74 0.22195
Cp1a74 p1a72 0 0.25838p
Cp1b74 p1b73 0 0.25838p
Cp1m74 p1a72 p1b73 0.0433125p
Rp1a79 p1a72 p1ra80 0.00558854
Rp1b79 p1b73 p1rb81 0.00558854
Lp1a79 p1ra80 p1a77 1.00306n
Lp1b79 p1rb81 p1b78 1.00306n
Kp179 Lp1a79 Lp1b79 0.22195
Cp1a79 p1a77 0 0.25838p
Cp1b79 p1b78 0 0.25838p
Cp1m79 p1a77 p1b78 0.0433125p
Rp1a84 p1a77 p1ra85 0.00558854
Rp1b84 p1b78 p1rb86 0.00558854
Lp1a84 p1ra85 p1a82 1.00306n
Lp1b84 p1rb86 p1b83 1.00306n
Kp184 Lp1a84 Lp1b84 0.22195
Cp1a84 p1a82 0 0.25838p
Cp1b84 p1b83 0 0.25838p
Cp1m84 p1a82 p1b83 0.0433125p
Rp1a89 p1a82 p1ra90 0.00558854
Rp1b89 p1b83 p1rb91 0.00558854
Lp1a89 p1ra90 p1a87 1.00306n
Lp1b89 p1rb91 p1b88 1.00306n
Kp189 Lp1a89 Lp1b89 0.22195
Cp1a89 p1a87 0 0.25838p
Cp1b89 p1b88 0 0.25838p
Cp1m89 p1a87 p1b88 0.0433125p
Rp1a94 p1a87 p1ra95 0.00558854
Rp1b94 p1b88 p1rb96 0.00558854
Lp1a94 p1ra95 p1a92 1.00306n
Lp1b94 p1rb96 p1b93 1.00306n
Kp194 Lp1a94 Lp1b94 0.22195
Cp1a94 p1a92 0 0.25838p
Cp1b94 p1b93 0 0.25838p
Cp1m94 p1a92 p1b93 0.0433125p
Rp1a99 p1a92 p1ra100 0.00558854
Rp1b99 p1b93 p1rb101 0.00558854
Lp1a99 p1ra100 p1a97 1.00306n
Lp1b99 p1rb101 p1b98 1.00306n
Kp199 Lp1a99 Lp1b99 0.22195
Cp1a99 p1a97 0 0.25838p
Cp1b99 p1b98 0 0.25838p
Cp1m99 p1a97 p1b98 0.0433125p
Rp1a104 p1a97 p1ra105 0.00558854
Rp1b104 p1b98 p1rb106 0.00558854
Lp1a104 p1ra105 p1a102 1.00306n
Lp1b104 p1rb106 p1b103 1.00306n
Kp1104 Lp1a104 Lp1b104 0.22195
Cp1a104 p1a102 0 0.25838p
Cp1b104 p1b103 0 0.25838p
Cp1m104 p1a102 p1b103 0.0433125p
Rp1a109 p1a102 p1ra110 0.00558854
Rp1b109 p1b103 p1rb111 0.00558854
Lp1a109 p1ra110 p1a107 1.00306n
Lp1b109 p1rb111 p1b108 1.00306n
Kp1109 Lp1a109 Lp1b109 0.22195
Cp1a109 p1a107 0 0.25838p
Cp1b109 p1b108 0 0.25838p
Cp1m109 p1a107 p1b108 0.0433125p
Rp1a114 p1a107 p1ra115 0.00558854
Rp1b114 p1b108 p1rb116 0.00558854
Lp1a114 p1ra115 p1a112 1.00306n
Lp1b114 p1rb116 p1b113 1.00306n
Kp1114 Lp1a114 Lp1b114 0.22195
Cp1a114 p1a112 0 0.25838p
Cp1b114 p1b113 0 0.25838p
Cp1m114 p1a112 p1b113 0.0433125p
Rp1a119 p1a112 p1ra120 0.00558854
Rp1b119 p1b113 p1rb121 0.00558854
Lp1a119 p1ra120 p1a117 1.00306n
Lp1b119 p1rb121 p1b118 1.00306n
Kp1119 Lp1a119 Lp1b119 0.22195
Cp1a119 p1a117 0 0.25838p
Cp1b119 p1b118 0 0.25838p
Cp1m119 p1a117 p1b118 0.0433125p
Rp1a124 p1a117 p1ra125 0.00558854
Rp1b124 p1b118 p1rb126 0.00558854
Lp1a124 p1ra125 p1a122 1.00306n
Lp1b124 p1rb126 p1b123 1.00306n
Kp1124 Lp1a124 Lp1b124 0.22195
Cp1a124 p1a122 0 0.25838p
Cp1b124 p1b123 0 0.25838p
Cp1m124 p1a122 p1b123 0.0433125p
Rp1a129 p1a122 p1ra130 0.00558854
Rp1b129 p1b123 p1rb131 0.00558854
Lp1a129 p1ra130 p1a127 1.00306n
Lp1b129 p1rb131 p1b128 1.00306n
Kp1129 Lp1a129 Lp1b129 0.22195
Cp1a129 p1a127 0 0.25838p
Cp1b129 p1b128 0 0.25838p
Cp1m129 p1a127 p1b128 0.0433125p
Rp1a132 p1a127 p1ra133 0.00558854
Rp1b132 p1b128 p1rb134 0.00558854
Lp1a132 p1ra133 dpx65 1.00306n
Lp1b132 p1rb134 dmx66 1.00306n
Kp1132 Lp1a132 Lp1b132 0.22195
Cp1a132 dpx65 0 0.25838p
Cp1b132 dmx66 0 0.25838p
Cp1m132 dpx65 dmx66 0.0433125p
Rj135 dpx65 dp63 1m
Rt137 dmx66 tm136 0.000157137
Lt137 tm136 dm64 0.0285507n
Ct137 dm64 0 0.00822381p
Rt142 dp63 tm141 0.00318077
Lt142 tm141 u140 0.427416n
Ct142 u140 0 0.0792514p
Lv144 u140 u143 1.358n
Cv144 u143 0 0.4885p
Rt146 u143 tm145 0.00144787
Lt146 tm145 dp138 0.194558n
Ct146 dp138 0 0.0360749p
Rt149 dm64 tm148 0.00243898
Lt149 tm148 u147 0.327737n
Ct149 u147 0 0.060769p
Lv151 u147 u150 1.358n
Cv151 u150 0 0.4885p
Rt153 u150 tm152 0.00230009
Lt153 tm152 dm139 0.309075n
Ct153 dm139 0 0.0573087p
Rp3a160 dp138 p3ra161 0.00576745
Rp3b160 dm139 p3rb162 0.00576745
Lp3a160 p3ra161 p3a158 1.03517n
Lp3b160 p3rb162 p3b159 1.03517n
Kp3160 Lp3a160 Lp3b160 0.22195
Cp3a160 p3a158 0 0.266651p
Cp3b160 p3b159 0 0.266651p
Cp3m160 p3a158 p3b159 0.0446991p
Rp3a165 p3a158 p3ra166 0.00576745
Rp3b165 p3b159 p3rb167 0.00576745
Lp3a165 p3ra166 p3a163 1.03517n
Lp3b165 p3rb167 p3b164 1.03517n
Kp3165 Lp3a165 Lp3b165 0.22195
Cp3a165 p3a163 0 0.266651p
Cp3b165 p3b164 0 0.266651p
Cp3m165 p3a163 p3b164 0.0446991p
Rp3a170 p3a163 p3ra171 0.00576745
Rp3b170 p3b164 p3rb172 0.00576745
Lp3a170 p3ra171 p3a168 1.03517n
Lp3b170 p3rb172 p3b169 1.03517n
Kp3170 Lp3a170 Lp3b170 0.22195
Cp3a170 p3a168 0 0.266651p
Cp3b170 p3b169 0 0.266651p
Cp3m170 p3a168 p3b169 0.0446991p
Rp3a175 p3a168 p3ra176 0.00576745
Rp3b175 p3b169 p3rb177 0.00576745
Lp3a175 p3ra176 p3a173 1.03517n
Lp3b175 p3rb177 p3b174 1.03517n
Kp3175 Lp3a175 Lp3b175 0.22195
Cp3a175 p3a173 0 0.266651p
Cp3b175 p3b174 0 0.266651p
Cp3m175 p3a173 p3b174 0.0446991p
Rp3a180 p3a173 p3ra181 0.00576745
Rp3b180 p3b174 p3rb182 0.00576745
Lp3a180 p3ra181 p3a178 1.03517n
Lp3b180 p3rb182 p3b179 1.03517n
Kp3180 Lp3a180 Lp3b180 0.22195
Cp3a180 p3a178 0 0.266651p
Cp3b180 p3b179 0 0.266651p
Cp3m180 p3a178 p3b179 0.0446991p
Rp3a185 p3a178 p3ra186 0.00576745
Rp3b185 p3b179 p3rb187 0.00576745
Lp3a185 p3ra186 p3a183 1.03517n
Lp3b185 p3rb187 p3b184 1.03517n
Kp3185 Lp3a185 Lp3b185 0.22195
Cp3a185 p3a183 0 0.266651p
Cp3b185 p3b184 0 0.266651p
Cp3m185 p3a183 p3b184 0.0446991p
Rp3a190 p3a183 p3ra191 0.00576745
Rp3b190 p3b184 p3rb192 0.00576745
Lp3a190 p3ra191 p3a188 1.03517n
Lp3b190 p3rb192 p3b189 1.03517n
Kp3190 Lp3a190 Lp3b190 0.22195
Cp3a190 p3a188 0 0.266651p
Cp3b190 p3b189 0 0.266651p
Cp3m190 p3a188 p3b189 0.0446991p
Rp3a195 p3a188 p3ra196 0.00576745
Rp3b195 p3b189 p3rb197 0.00576745
Lp3a195 p3ra196 p3a193 1.03517n
Lp3b195 p3rb197 p3b194 1.03517n
Kp3195 Lp3a195 Lp3b195 0.22195
Cp3a195 p3a193 0 0.266651p
Cp3b195 p3b194 0 0.266651p
Cp3m195 p3a193 p3b194 0.0446991p
Rp3a200 p3a193 p3ra201 0.00576745
Rp3b200 p3b194 p3rb202 0.00576745
Lp3a200 p3ra201 p3a198 1.03517n
Lp3b200 p3rb202 p3b199 1.03517n
Kp3200 Lp3a200 Lp3b200 0.22195
Cp3a200 p3a198 0 0.266651p
Cp3b200 p3b199 0 0.266651p
Cp3m200 p3a198 p3b199 0.0446991p
Rp3a205 p3a198 p3ra206 0.00576745
Rp3b205 p3b199 p3rb207 0.00576745
Lp3a205 p3ra206 p3a203 1.03517n
Lp3b205 p3rb207 p3b204 1.03517n
Kp3205 Lp3a205 Lp3b205 0.22195
Cp3a205 p3a203 0 0.266651p
Cp3b205 p3b204 0 0.266651p
Cp3m205 p3a203 p3b204 0.0446991p
Rp3a210 p3a203 p3ra211 0.00576745
Rp3b210 p3b204 p3rb212 0.00576745
Lp3a210 p3ra211 p3a208 1.03517n
Lp3b210 p3rb212 p3b209 1.03517n
Kp3210 Lp3a210 Lp3b210 0.22195
Cp3a210 p3a208 0 0.266651p
Cp3b210 p3b209 0 0.266651p
Cp3m210 p3a208 p3b209 0.0446991p
Rp3a215 p3a208 p3ra216 0.00576745
Rp3b215 p3b209 p3rb217 0.00576745
Lp3a215 p3ra216 p3a213 1.03517n
Lp3b215 p3rb217 p3b214 1.03517n
Kp3215 Lp3a215 Lp3b215 0.22195
Cp3a215 p3a213 0 0.266651p
Cp3b215 p3b214 0 0.266651p
Cp3m215 p3a213 p3b214 0.0446991p
Rp3a220 p3a213 p3ra221 0.00576745
Rp3b220 p3b214 p3rb222 0.00576745
Lp3a220 p3ra221 p3a218 1.03517n
Lp3b220 p3rb222 p3b219 1.03517n
Kp3220 Lp3a220 Lp3b220 0.22195
Cp3a220 p3a218 0 0.266651p
Cp3b220 p3b219 0 0.266651p
Cp3m220 p3a218 p3b219 0.0446991p
Rp3a225 p3a218 p3ra226 0.00576745
Rp3b225 p3b219 p3rb227 0.00576745
Lp3a225 p3ra226 p3a223 1.03517n
Lp3b225 p3rb227 p3b224 1.03517n
Kp3225 Lp3a225 Lp3b225 0.22195
Cp3a225 p3a223 0 0.266651p
Cp3b225 p3b224 0 0.266651p
Cp3m225 p3a223 p3b224 0.0446991p
Rp3a230 p3a223 p3ra231 0.00576745
Rp3b230 p3b224 p3rb232 0.00576745
Lp3a230 p3ra231 p3a228 1.03517n
Lp3b230 p3rb232 p3b229 1.03517n
Kp3230 Lp3a230 Lp3b230 0.22195
Cp3a230 p3a228 0 0.266651p
Cp3b230 p3b229 0 0.266651p
Cp3m230 p3a228 p3b229 0.0446991p
Rp3a235 p3a228 p3ra236 0.00576745
Rp3b235 p3b229 p3rb237 0.00576745
Lp3a235 p3ra236 p3a233 1.03517n
Lp3b235 p3rb237 p3b234 1.03517n
Kp3235 Lp3a235 Lp3b235 0.22195
Cp3a235 p3a233 0 0.266651p
Cp3b235 p3b234 0 0.266651p
Cp3m235 p3a233 p3b234 0.0446991p
Rp3a240 p3a233 p3ra241 0.00576745
Rp3b240 p3b234 p3rb242 0.00576745
Lp3a240 p3ra241 p3a238 1.03517n
Lp3b240 p3rb242 p3b239 1.03517n
Kp3240 Lp3a240 Lp3b240 0.22195
Cp3a240 p3a238 0 0.266651p
Cp3b240 p3b239 0 0.266651p
Cp3m240 p3a238 p3b239 0.0446991p
Rp3a245 p3a238 p3ra246 0.00576745
Rp3b245 p3b239 p3rb247 0.00576745
Lp3a245 p3ra246 p3a243 1.03517n
Lp3b245 p3rb247 p3b244 1.03517n
Kp3245 Lp3a245 Lp3b245 0.22195
Cp3a245 p3a243 0 0.266651p
Cp3b245 p3b244 0 0.266651p
Cp3m245 p3a243 p3b244 0.0446991p
Rp3a250 p3a243 p3ra251 0.00576745
Rp3b250 p3b244 p3rb252 0.00576745
Lp3a250 p3ra251 p3a248 1.03517n
Lp3b250 p3rb252 p3b249 1.03517n
Kp3250 Lp3a250 Lp3b250 0.22195
Cp3a250 p3a248 0 0.266651p
Cp3b250 p3b249 0 0.266651p
Cp3m250 p3a248 p3b249 0.0446991p
Rp3a255 p3a248 p3ra256 0.00576745
Rp3b255 p3b249 p3rb257 0.00576745
Lp3a255 p3ra256 p3a253 1.03517n
Lp3b255 p3rb257 p3b254 1.03517n
Kp3255 Lp3a255 Lp3b255 0.22195
Cp3a255 p3a253 0 0.266651p
Cp3b255 p3b254 0 0.266651p
Cp3m255 p3a253 p3b254 0.0446991p
Rp3a260 p3a253 p3ra261 0.00576745
Rp3b260 p3b254 p3rb262 0.00576745
Lp3a260 p3ra261 p3a258 1.03517n
Lp3b260 p3rb262 p3b259 1.03517n
Kp3260 Lp3a260 Lp3b260 0.22195
Cp3a260 p3a258 0 0.266651p
Cp3b260 p3b259 0 0.266651p
Cp3m260 p3a258 p3b259 0.0446991p
Rp3a265 p3a258 p3ra266 0.00576745
Rp3b265 p3b259 p3rb267 0.00576745
Lp3a265 p3ra266 p3a263 1.03517n
Lp3b265 p3rb267 p3b264 1.03517n
Kp3265 Lp3a265 Lp3b265 0.22195
Cp3a265 p3a263 0 0.266651p
Cp3b265 p3b264 0 0.266651p
Cp3m265 p3a263 p3b264 0.0446991p
Rp3a270 p3a263 p3ra271 0.00576745
Rp3b270 p3b264 p3rb272 0.00576745
Lp3a270 p3ra271 p3a268 1.03517n
Lp3b270 p3rb272 p3b269 1.03517n
Kp3270 Lp3a270 Lp3b270 0.22195
Cp3a270 p3a268 0 0.266651p
Cp3b270 p3b269 0 0.266651p
Cp3m270 p3a268 p3b269 0.0446991p
Rp3a275 p3a268 p3ra276 0.00576745
Rp3b275 p3b269 p3rb277 0.00576745
Lp3a275 p3ra276 p3a273 1.03517n
Lp3b275 p3rb277 p3b274 1.03517n
Kp3275 Lp3a275 Lp3b275 0.22195
Cp3a275 p3a273 0 0.266651p
Cp3b275 p3b274 0 0.266651p
Cp3m275 p3a273 p3b274 0.0446991p
Rp3a280 p3a273 p3ra281 0.00576745
Rp3b280 p3b274 p3rb282 0.00576745
Lp3a280 p3ra281 p3a278 1.03517n
Lp3b280 p3rb282 p3b279 1.03517n
Kp3280 Lp3a280 Lp3b280 0.22195
Cp3a280 p3a278 0 0.266651p
Cp3b280 p3b279 0 0.266651p
Cp3m280 p3a278 p3b279 0.0446991p
Rp3a285 p3a278 p3ra286 0.00576745
Rp3b285 p3b279 p3rb287 0.00576745
Lp3a285 p3ra286 p3a283 1.03517n
Lp3b285 p3rb287 p3b284 1.03517n
Kp3285 Lp3a285 Lp3b285 0.22195
Cp3a285 p3a283 0 0.266651p
Cp3b285 p3b284 0 0.266651p
Cp3m285 p3a283 p3b284 0.0446991p
Rp3a290 p3a283 p3ra291 0.00576745
Rp3b290 p3b284 p3rb292 0.00576745
Lp3a290 p3ra291 p3a288 1.03517n
Lp3b290 p3rb292 p3b289 1.03517n
Kp3290 Lp3a290 Lp3b290 0.22195
Cp3a290 p3a288 0 0.266651p
Cp3b290 p3b289 0 0.266651p
Cp3m290 p3a288 p3b289 0.0446991p
Rp3a293 p3a288 p3ra294 0.00576745
Rp3b293 p3b289 p3rb295 0.00576745
Lp3a293 p3ra294 dpx156 1.03517n
Lp3b293 p3rb295 dmx157 1.03517n
Kp3293 Lp3a293 Lp3b293 0.22195
Cp3a293 dpx156 0 0.266651p
Cp3b293 dmx157 0 0.266651p
Cp3m293 dpx156 dmx157 0.0446991p
Rj296 dpx156 dp154 1m
Rt298 dmx157 tm297 0.000757596
Lt298 tm297 dm155 0.13765n
Ct298 dm155 0 0.039649p
Rt303 dp154 tm302 0.00643789
Lt303 tm302 u301 0.86509n
Ct303 u301 0 0.160405p
Lv305 u301 u304 1.358n
Cv305 u304 0 0.4885p
Rt308 u304 tm306 0.0033742
Lt308 tm306 t307 0.453408n
Ct308 t307 0 0.0840709p
Rt310 t307 tm309 0.0033742
Lt310 tm309 dp299 0.453408n
Ct310 dp299 0 0.0840709p
Rt313 dm155 tm312 0.00628268
Lt313 tm312 u311 0.844235n
Ct313 u311 0 0.156538p
Lv315 u311 u314 1.358n
Cv315 u314 0 0.4885p
Rt317 u314 tm316 0.00627529
Lt317 tm316 dm300 0.843241n
Ct317 dm300 0 0.156354p
Rp5a324 dp299 p5ra325 0.00516254
Rp5b324 dm300 p5rb326 0.00516254
Lp5a324 p5ra325 p5a322 0.926596n
Lp5b324 p5rb326 p5b323 0.926596n
Kp5324 Lp5a324 Lp5b324 0.22195
Cp5a324 p5a322 0 0.238684p
Cp5b324 p5b323 0 0.238684p
Cp5m324 p5a322 p5b323 0.0400109p
Rp5a329 p5a322 p5ra330 0.00516254
Rp5b329 p5b323 p5rb331 0.00516254
Lp5a329 p5ra330 p5a327 0.926596n
Lp5b329 p5rb331 p5b328 0.926596n
Kp5329 Lp5a329 Lp5b329 0.22195
Cp5a329 p5a327 0 0.238684p
Cp5b329 p5b328 0 0.238684p
Cp5m329 p5a327 p5b328 0.0400109p
Rp5a334 p5a327 p5ra335 0.00516254
Rp5b334 p5b328 p5rb336 0.00516254
Lp5a334 p5ra335 p5a332 0.926596n
Lp5b334 p5rb336 p5b333 0.926596n
Kp5334 Lp5a334 Lp5b334 0.22195
Cp5a334 p5a332 0 0.238684p
Cp5b334 p5b333 0 0.238684p
Cp5m334 p5a332 p5b333 0.0400109p
Rp5a339 p5a332 p5ra340 0.00516254
Rp5b339 p5b333 p5rb341 0.00516254
Lp5a339 p5ra340 p5a337 0.926596n
Lp5b339 p5rb341 p5b338 0.926596n
Kp5339 Lp5a339 Lp5b339 0.22195
Cp5a339 p5a337 0 0.238684p
Cp5b339 p5b338 0 0.238684p
Cp5m339 p5a337 p5b338 0.0400109p
Rp5a344 p5a337 p5ra345 0.00516254
Rp5b344 p5b338 p5rb346 0.00516254
Lp5a344 p5ra345 p5a342 0.926596n
Lp5b344 p5rb346 p5b343 0.926596n
Kp5344 Lp5a344 Lp5b344 0.22195
Cp5a344 p5a342 0 0.238684p
Cp5b344 p5b343 0 0.238684p
Cp5m344 p5a342 p5b343 0.0400109p
Rp5a347 p5a342 p5ra348 0.00516254
Rp5b347 p5b343 p5rb349 0.00516254
Lp5a347 p5ra348 dpx320 0.926596n
Lp5b347 p5rb349 dmx321 0.926596n
Kp5347 Lp5a347 Lp5b347 0.22195
Cp5a347 dpx320 0 0.238684p
Cp5b347 dmx321 0 0.238684p
Cp5m347 dpx320 dmx321 0.0400109p
Rt352 dpx320 tm350 0.00246864
Lt352 tm350 t351 0.448535n
Ct352 t351 0 0.129197p
Rt354 t351 tm353 0.00246864
Lt354 tm353 dp318 0.448535n
Ct354 dp318 0 0.129197p
Rj355 dmx321 dm319 1m
Lv357 dp318 u356 1.358n
Cv357 u356 0 0.4885p
Rt360 u356 tm358 0.00343926
Lt360 tm358 t359 0.46215n
Ct360 t359 0 0.0856918p
Rt362 t359 tm361 0.00343926
Lt362 tm361 rp_b 0.46215n
Ct362 rp_b 0 0.0856918p
Lv364 dm319 u363 1.358n
Cv364 u363 0 0.4885p
Rt367 u363 tm365 0.00342362
Lt367 tm365 t366 0.460048n
Ct367 t366 0 0.0853021p
Rt369 t366 tm368 0.00342362
Lt369 tm368 rm_b 0.460048n
Ct369 rm_b 0 0.0853021p
Cu10p conp 0 0.7p
Cu10m conm 0 0.7p
Rst373 conp stm371 0.00495442
Lst373 stm371 st372 0.665749n
Cst373 st372 0 0.123443p
Rst376 st372 stm374 0.00495442
Lst376 stm374 st375 0.665749n
Cst376 st375 0 0.123443p
Rst379 st375 stm377 0.00495442
Lst379 stm377 st378 0.665749n
Cst379 st378 0 0.123443p
Rst381 st378 stm380 0.00495442
Lst381 stm380 st370 0.665749n
Cst381 st370 0 0.123443p
Cst382 st370 0 0.3p
Rst386 conm stm384 0.00388229
Lst386 stm384 st385 0.521681n
Cst386 st385 0 0.0967302p
Rst388 st385 stm387 0.00388229
Lst388 stm387 st383 0.521681n
Cst388 st383 0 0.0967302p
Cst389 st383 0 0.3p
Cconp conp 0 0.6p
Cconm conm 0 0.6p
.options method=gear reltol=1e-3
.tran 0.01n 8n 0 0.02n
.control
set wr_singlescale
set wr_vecnames
set numdgt=7
run

wrdata /out/usb_delay.txt v(conp) v(conm) v(pinp) v(pinm) v(rp_b) v(rm_b)
.endc
.end
