* USB: propagation delay from the J1 pads to the RP2350 pins (one differential edge, matched ends)
Vp sp 0 PWL(0 0 2n 0 3n 3.3)
Vm sm 0 PWL(0 3.3 2n 3.3 3n 0)
Rsp sp conp 45
Rsm sm conm 45
Rtp pinp 0 20
Rtm pinm 0 20
Rt3 pinp tm1 0.0026891
Lt3 tm1 t2 0.361347n
Ct3 t2 0 0.067001p
Rt6 t2 tm4 0.0026891
Lt6 tm4 t5 0.361347n
Ct6 t5 0 0.067001p
Rt9 t5 tm7 0.0026891
Lt9 tm7 t8 0.361347n
Ct9 t8 0 0.067001p
Rt12 t8 tm10 0.0026891
Lt12 tm10 t11 0.361347n
Ct12 t11 0 0.067001p
Rt14 t11 tm13 0.0026891
Lt14 tm13 rp_a 0.361347n
Ct14 rp_a 0 0.067001p
Rt17 pinm tm15 0.00312876
Lt17 tm15 t16 0.420427n
Ct17 t16 0 0.0779556p
Rt20 t16 tm18 0.00312876
Lt20 tm18 t19 0.420427n
Ct20 t19 0 0.0779556p
Rt23 t19 tm21 0.00312876
Lt23 tm21 t22 0.420427n
Ct23 t22 0 0.0779556p
Rt25 t22 tm24 0.00312876
Lt25 tm24 rm_a 0.420427n
Ct25 rm_a 0 0.0779556p
R102 rp_a rp_b 27
R103 rm_a rm_b 27
Rt30 conp tm29 0.0030141
Lt30 tm29 u28 0.405019n
Ct30 u28 0 0.0750985p
Lv32 u28 u31 1.358n
Cv32 u31 0 0.4885p
Rt35 u31 tm33 0.00562666
Lt35 tm33 t34 0.756081n
Ct35 t34 0 0.140193p
Rt38 t34 tm36 0.00562666
Lt38 tm36 t37 0.756081n
Ct38 t37 0 0.140193p
Rt40 t37 tm39 0.00562666
Lt40 tm39 dp26 0.756081n
Ct40 dp26 0 0.140193p
Rt43 conm tm42 0.00582544
Lt43 tm42 u41 0.782792n
Ct43 u41 0 0.145145p
Lv45 u41 u44 1.358n
Cv45 u44 0 0.4885p
Rt48 u44 tm46 0.00468437
Lt48 tm46 t47 0.629461n
Ct48 t47 0 0.116715p
Rt51 t47 tm49 0.00468437
Lt51 tm49 t50 0.629461n
Ct51 t50 0 0.116715p
Rt53 t50 tm52 0.00468437
Lt53 tm52 dm27 0.629461n
Ct53 dm27 0 0.116715p
Rp1a60 dp26 p1ra61 0.00578857
Rp1b60 dm27 p1rb62 0.00578857
Lp1a60 p1ra61 p1a58 1.03896n
Lp1b60 p1rb62 p1b59 1.03896n
Kp160 Lp1a60 Lp1b60 0.22195
Cp1a60 p1a58 0 0.267628p
Cp1b60 p1b59 0 0.267628p
Cp1m60 p1a58 p1b59 0.0448628p
Rp1a65 p1a58 p1ra66 0.00578857
Rp1b65 p1b59 p1rb67 0.00578857
Lp1a65 p1ra66 p1a63 1.03896n
Lp1b65 p1rb67 p1b64 1.03896n
Kp165 Lp1a65 Lp1b65 0.22195
Cp1a65 p1a63 0 0.267628p
Cp1b65 p1b64 0 0.267628p
Cp1m65 p1a63 p1b64 0.0448628p
Rp1a70 p1a63 p1ra71 0.00578857
Rp1b70 p1b64 p1rb72 0.00578857
Lp1a70 p1ra71 p1a68 1.03896n
Lp1b70 p1rb72 p1b69 1.03896n
Kp170 Lp1a70 Lp1b70 0.22195
Cp1a70 p1a68 0 0.267628p
Cp1b70 p1b69 0 0.267628p
Cp1m70 p1a68 p1b69 0.0448628p
Rp1a75 p1a68 p1ra76 0.00578857
Rp1b75 p1b69 p1rb77 0.00578857
Lp1a75 p1ra76 p1a73 1.03896n
Lp1b75 p1rb77 p1b74 1.03896n
Kp175 Lp1a75 Lp1b75 0.22195
Cp1a75 p1a73 0 0.267628p
Cp1b75 p1b74 0 0.267628p
Cp1m75 p1a73 p1b74 0.0448628p
Rp1a80 p1a73 p1ra81 0.00578857
Rp1b80 p1b74 p1rb82 0.00578857
Lp1a80 p1ra81 p1a78 1.03896n
Lp1b80 p1rb82 p1b79 1.03896n
Kp180 Lp1a80 Lp1b80 0.22195
Cp1a80 p1a78 0 0.267628p
Cp1b80 p1b79 0 0.267628p
Cp1m80 p1a78 p1b79 0.0448628p
Rp1a85 p1a78 p1ra86 0.00578857
Rp1b85 p1b79 p1rb87 0.00578857
Lp1a85 p1ra86 p1a83 1.03896n
Lp1b85 p1rb87 p1b84 1.03896n
Kp185 Lp1a85 Lp1b85 0.22195
Cp1a85 p1a83 0 0.267628p
Cp1b85 p1b84 0 0.267628p
Cp1m85 p1a83 p1b84 0.0448628p
Rp1a90 p1a83 p1ra91 0.00578857
Rp1b90 p1b84 p1rb92 0.00578857
Lp1a90 p1ra91 p1a88 1.03896n
Lp1b90 p1rb92 p1b89 1.03896n
Kp190 Lp1a90 Lp1b90 0.22195
Cp1a90 p1a88 0 0.267628p
Cp1b90 p1b89 0 0.267628p
Cp1m90 p1a88 p1b89 0.0448628p
Rp1a95 p1a88 p1ra96 0.00578857
Rp1b95 p1b89 p1rb97 0.00578857
Lp1a95 p1ra96 p1a93 1.03896n
Lp1b95 p1rb97 p1b94 1.03896n
Kp195 Lp1a95 Lp1b95 0.22195
Cp1a95 p1a93 0 0.267628p
Cp1b95 p1b94 0 0.267628p
Cp1m95 p1a93 p1b94 0.0448628p
Rp1a100 p1a93 p1ra101 0.00578857
Rp1b100 p1b94 p1rb102 0.00578857
Lp1a100 p1ra101 p1a98 1.03896n
Lp1b100 p1rb102 p1b99 1.03896n
Kp1100 Lp1a100 Lp1b100 0.22195
Cp1a100 p1a98 0 0.267628p
Cp1b100 p1b99 0 0.267628p
Cp1m100 p1a98 p1b99 0.0448628p
Rp1a105 p1a98 p1ra106 0.00578857
Rp1b105 p1b99 p1rb107 0.00578857
Lp1a105 p1ra106 p1a103 1.03896n
Lp1b105 p1rb107 p1b104 1.03896n
Kp1105 Lp1a105 Lp1b105 0.22195
Cp1a105 p1a103 0 0.267628p
Cp1b105 p1b104 0 0.267628p
Cp1m105 p1a103 p1b104 0.0448628p
Rp1a110 p1a103 p1ra111 0.00578857
Rp1b110 p1b104 p1rb112 0.00578857
Lp1a110 p1ra111 p1a108 1.03896n
Lp1b110 p1rb112 p1b109 1.03896n
Kp1110 Lp1a110 Lp1b110 0.22195
Cp1a110 p1a108 0 0.267628p
Cp1b110 p1b109 0 0.267628p
Cp1m110 p1a108 p1b109 0.0448628p
Rp1a115 p1a108 p1ra116 0.00578857
Rp1b115 p1b109 p1rb117 0.00578857
Lp1a115 p1ra116 p1a113 1.03896n
Lp1b115 p1rb117 p1b114 1.03896n
Kp1115 Lp1a115 Lp1b115 0.22195
Cp1a115 p1a113 0 0.267628p
Cp1b115 p1b114 0 0.267628p
Cp1m115 p1a113 p1b114 0.0448628p
Rp1a118 p1a113 p1ra119 0.00578857
Rp1b118 p1b114 p1rb120 0.00578857
Lp1a118 p1ra119 dpx56 1.03896n
Lp1b118 p1rb120 dmx57 1.03896n
Kp1118 Lp1a118 Lp1b118 0.22195
Cp1a118 dpx56 0 0.267628p
Cp1b118 dmx57 0 0.267628p
Cp1m118 dpx56 dmx57 0.0448628p
Rt122 dpx56 tm121 9.08444e-06
Lt122 tm121 dp54 0.00165058n
Ct122 dp54 0 0.000475437p
Rj123 dmx57 dm55 1m
Lv126 dp54 dp124 1.358n
Cv126 dp124 0 0.4885p
Lv127 dm55 dm125 1.358n
Cv127 dm125 0 0.4885p
Rp3a134 dp124 p3ra135 0.0057538
Rp3b134 dm125 p3rb136 0.0057538
Lp3a134 p3ra135 p3a132 1.03272n
Lp3b134 p3rb136 p3b133 1.03272n
Kp3134 Lp3a134 Lp3b134 0.22195
Cp3a134 p3a132 0 0.26602p
Cp3b134 p3b133 0 0.26602p
Cp3m134 p3a132 p3b133 0.0445933p
Rp3a139 p3a132 p3ra140 0.0057538
Rp3b139 p3b133 p3rb141 0.0057538
Lp3a139 p3ra140 p3a137 1.03272n
Lp3b139 p3rb141 p3b138 1.03272n
Kp3139 Lp3a139 Lp3b139 0.22195
Cp3a139 p3a137 0 0.26602p
Cp3b139 p3b138 0 0.26602p
Cp3m139 p3a137 p3b138 0.0445933p
Rp3a144 p3a137 p3ra145 0.0057538
Rp3b144 p3b138 p3rb146 0.0057538
Lp3a144 p3ra145 p3a142 1.03272n
Lp3b144 p3rb146 p3b143 1.03272n
Kp3144 Lp3a144 Lp3b144 0.22195
Cp3a144 p3a142 0 0.26602p
Cp3b144 p3b143 0 0.26602p
Cp3m144 p3a142 p3b143 0.0445933p
Rp3a149 p3a142 p3ra150 0.0057538
Rp3b149 p3b143 p3rb151 0.0057538
Lp3a149 p3ra150 p3a147 1.03272n
Lp3b149 p3rb151 p3b148 1.03272n
Kp3149 Lp3a149 Lp3b149 0.22195
Cp3a149 p3a147 0 0.26602p
Cp3b149 p3b148 0 0.26602p
Cp3m149 p3a147 p3b148 0.0445933p
Rp3a154 p3a147 p3ra155 0.0057538
Rp3b154 p3b148 p3rb156 0.0057538
Lp3a154 p3ra155 p3a152 1.03272n
Lp3b154 p3rb156 p3b153 1.03272n
Kp3154 Lp3a154 Lp3b154 0.22195
Cp3a154 p3a152 0 0.26602p
Cp3b154 p3b153 0 0.26602p
Cp3m154 p3a152 p3b153 0.0445933p
Rp3a159 p3a152 p3ra160 0.0057538
Rp3b159 p3b153 p3rb161 0.0057538
Lp3a159 p3ra160 p3a157 1.03272n
Lp3b159 p3rb161 p3b158 1.03272n
Kp3159 Lp3a159 Lp3b159 0.22195
Cp3a159 p3a157 0 0.26602p
Cp3b159 p3b158 0 0.26602p
Cp3m159 p3a157 p3b158 0.0445933p
Rp3a164 p3a157 p3ra165 0.0057538
Rp3b164 p3b158 p3rb166 0.0057538
Lp3a164 p3ra165 p3a162 1.03272n
Lp3b164 p3rb166 p3b163 1.03272n
Kp3164 Lp3a164 Lp3b164 0.22195
Cp3a164 p3a162 0 0.26602p
Cp3b164 p3b163 0 0.26602p
Cp3m164 p3a162 p3b163 0.0445933p
Rp3a169 p3a162 p3ra170 0.0057538
Rp3b169 p3b163 p3rb171 0.0057538
Lp3a169 p3ra170 p3a167 1.03272n
Lp3b169 p3rb171 p3b168 1.03272n
Kp3169 Lp3a169 Lp3b169 0.22195
Cp3a169 p3a167 0 0.26602p
Cp3b169 p3b168 0 0.26602p
Cp3m169 p3a167 p3b168 0.0445933p
Rp3a174 p3a167 p3ra175 0.0057538
Rp3b174 p3b168 p3rb176 0.0057538
Lp3a174 p3ra175 p3a172 1.03272n
Lp3b174 p3rb176 p3b173 1.03272n
Kp3174 Lp3a174 Lp3b174 0.22195
Cp3a174 p3a172 0 0.26602p
Cp3b174 p3b173 0 0.26602p
Cp3m174 p3a172 p3b173 0.0445933p
Rp3a179 p3a172 p3ra180 0.0057538
Rp3b179 p3b173 p3rb181 0.0057538
Lp3a179 p3ra180 p3a177 1.03272n
Lp3b179 p3rb181 p3b178 1.03272n
Kp3179 Lp3a179 Lp3b179 0.22195
Cp3a179 p3a177 0 0.26602p
Cp3b179 p3b178 0 0.26602p
Cp3m179 p3a177 p3b178 0.0445933p
Rp3a184 p3a177 p3ra185 0.0057538
Rp3b184 p3b178 p3rb186 0.0057538
Lp3a184 p3ra185 p3a182 1.03272n
Lp3b184 p3rb186 p3b183 1.03272n
Kp3184 Lp3a184 Lp3b184 0.22195
Cp3a184 p3a182 0 0.26602p
Cp3b184 p3b183 0 0.26602p
Cp3m184 p3a182 p3b183 0.0445933p
Rp3a189 p3a182 p3ra190 0.0057538
Rp3b189 p3b183 p3rb191 0.0057538
Lp3a189 p3ra190 p3a187 1.03272n
Lp3b189 p3rb191 p3b188 1.03272n
Kp3189 Lp3a189 Lp3b189 0.22195
Cp3a189 p3a187 0 0.26602p
Cp3b189 p3b188 0 0.26602p
Cp3m189 p3a187 p3b188 0.0445933p
Rp3a194 p3a187 p3ra195 0.0057538
Rp3b194 p3b188 p3rb196 0.0057538
Lp3a194 p3ra195 p3a192 1.03272n
Lp3b194 p3rb196 p3b193 1.03272n
Kp3194 Lp3a194 Lp3b194 0.22195
Cp3a194 p3a192 0 0.26602p
Cp3b194 p3b193 0 0.26602p
Cp3m194 p3a192 p3b193 0.0445933p
Rp3a199 p3a192 p3ra200 0.0057538
Rp3b199 p3b193 p3rb201 0.0057538
Lp3a199 p3ra200 p3a197 1.03272n
Lp3b199 p3rb201 p3b198 1.03272n
Kp3199 Lp3a199 Lp3b199 0.22195
Cp3a199 p3a197 0 0.26602p
Cp3b199 p3b198 0 0.26602p
Cp3m199 p3a197 p3b198 0.0445933p
Rp3a204 p3a197 p3ra205 0.0057538
Rp3b204 p3b198 p3rb206 0.0057538
Lp3a204 p3ra205 p3a202 1.03272n
Lp3b204 p3rb206 p3b203 1.03272n
Kp3204 Lp3a204 Lp3b204 0.22195
Cp3a204 p3a202 0 0.26602p
Cp3b204 p3b203 0 0.26602p
Cp3m204 p3a202 p3b203 0.0445933p
Rp3a209 p3a202 p3ra210 0.0057538
Rp3b209 p3b203 p3rb211 0.0057538
Lp3a209 p3ra210 p3a207 1.03272n
Lp3b209 p3rb211 p3b208 1.03272n
Kp3209 Lp3a209 Lp3b209 0.22195
Cp3a209 p3a207 0 0.26602p
Cp3b209 p3b208 0 0.26602p
Cp3m209 p3a207 p3b208 0.0445933p
Rp3a214 p3a207 p3ra215 0.0057538
Rp3b214 p3b208 p3rb216 0.0057538
Lp3a214 p3ra215 p3a212 1.03272n
Lp3b214 p3rb216 p3b213 1.03272n
Kp3214 Lp3a214 Lp3b214 0.22195
Cp3a214 p3a212 0 0.26602p
Cp3b214 p3b213 0 0.26602p
Cp3m214 p3a212 p3b213 0.0445933p
Rp3a219 p3a212 p3ra220 0.0057538
Rp3b219 p3b213 p3rb221 0.0057538
Lp3a219 p3ra220 p3a217 1.03272n
Lp3b219 p3rb221 p3b218 1.03272n
Kp3219 Lp3a219 Lp3b219 0.22195
Cp3a219 p3a217 0 0.26602p
Cp3b219 p3b218 0 0.26602p
Cp3m219 p3a217 p3b218 0.0445933p
Rp3a224 p3a217 p3ra225 0.0057538
Rp3b224 p3b218 p3rb226 0.0057538
Lp3a224 p3ra225 p3a222 1.03272n
Lp3b224 p3rb226 p3b223 1.03272n
Kp3224 Lp3a224 Lp3b224 0.22195
Cp3a224 p3a222 0 0.26602p
Cp3b224 p3b223 0 0.26602p
Cp3m224 p3a222 p3b223 0.0445933p
Rp3a229 p3a222 p3ra230 0.0057538
Rp3b229 p3b223 p3rb231 0.0057538
Lp3a229 p3ra230 p3a227 1.03272n
Lp3b229 p3rb231 p3b228 1.03272n
Kp3229 Lp3a229 Lp3b229 0.22195
Cp3a229 p3a227 0 0.26602p
Cp3b229 p3b228 0 0.26602p
Cp3m229 p3a227 p3b228 0.0445933p
Rp3a234 p3a227 p3ra235 0.0057538
Rp3b234 p3b228 p3rb236 0.0057538
Lp3a234 p3ra235 p3a232 1.03272n
Lp3b234 p3rb236 p3b233 1.03272n
Kp3234 Lp3a234 Lp3b234 0.22195
Cp3a234 p3a232 0 0.26602p
Cp3b234 p3b233 0 0.26602p
Cp3m234 p3a232 p3b233 0.0445933p
Rp3a239 p3a232 p3ra240 0.0057538
Rp3b239 p3b233 p3rb241 0.0057538
Lp3a239 p3ra240 p3a237 1.03272n
Lp3b239 p3rb241 p3b238 1.03272n
Kp3239 Lp3a239 Lp3b239 0.22195
Cp3a239 p3a237 0 0.26602p
Cp3b239 p3b238 0 0.26602p
Cp3m239 p3a237 p3b238 0.0445933p
Rp3a244 p3a237 p3ra245 0.0057538
Rp3b244 p3b238 p3rb246 0.0057538
Lp3a244 p3ra245 p3a242 1.03272n
Lp3b244 p3rb246 p3b243 1.03272n
Kp3244 Lp3a244 Lp3b244 0.22195
Cp3a244 p3a242 0 0.26602p
Cp3b244 p3b243 0 0.26602p
Cp3m244 p3a242 p3b243 0.0445933p
Rp3a249 p3a242 p3ra250 0.0057538
Rp3b249 p3b243 p3rb251 0.0057538
Lp3a249 p3ra250 p3a247 1.03272n
Lp3b249 p3rb251 p3b248 1.03272n
Kp3249 Lp3a249 Lp3b249 0.22195
Cp3a249 p3a247 0 0.26602p
Cp3b249 p3b248 0 0.26602p
Cp3m249 p3a247 p3b248 0.0445933p
Rp3a254 p3a247 p3ra255 0.0057538
Rp3b254 p3b248 p3rb256 0.0057538
Lp3a254 p3ra255 p3a252 1.03272n
Lp3b254 p3rb256 p3b253 1.03272n
Kp3254 Lp3a254 Lp3b254 0.22195
Cp3a254 p3a252 0 0.26602p
Cp3b254 p3b253 0 0.26602p
Cp3m254 p3a252 p3b253 0.0445933p
Rp3a257 p3a252 p3ra258 0.0057538
Rp3b257 p3b253 p3rb259 0.0057538
Lp3a257 p3ra258 dpx130 1.03272n
Lp3b257 p3rb259 dmx131 1.03272n
Kp3257 Lp3a257 Lp3b257 0.22195
Cp3a257 dpx130 0 0.26602p
Cp3b257 dmx131 0 0.26602p
Cp3m257 dpx130 dmx131 0.0445933p
Rj260 dpx130 dp128 1m
Rt262 dmx131 tm261 3.33044e-05
Lt262 tm261 dm129 0.00605117n
Ct262 dm129 0 0.00174299p
Rt267 dp128 tm266 0.00643789
Lt267 tm266 u265 0.86509n
Ct267 u265 0 0.160405p
Lv269 u265 u268 1.358n
Cv269 u268 0 0.4885p
Rt272 u268 tm270 0.0033742
Lt272 tm270 t271 0.453408n
Ct272 t271 0 0.0840709p
Rt274 t271 tm273 0.0033742
Lt274 tm273 dp263 0.453408n
Ct274 dp263 0 0.0840709p
Rt277 dm129 tm276 0.00628268
Lt277 tm276 u275 0.844235n
Ct277 u275 0 0.156538p
Lv279 u275 u278 1.358n
Cv279 u278 0 0.4885p
Rt281 u278 tm280 0.00627529
Lt281 tm280 dm264 0.843241n
Ct281 dm264 0 0.156354p
Rp5a288 dp263 p5ra289 0.00469128
Rp5b288 dm264 p5rb290 0.00469128
Lp5a288 p5ra289 p5a286 0.842013n
Lp5b288 p5rb290 p5b287 0.842013n
Kp5288 Lp5a288 Lp5b288 0.22195
Cp5a288 p5a286 0 0.216896p
Cp5b288 p5b287 0 0.216896p
Cp5m288 p5a286 p5b287 0.0363586p
Rp5a293 p5a286 p5ra294 0.00469128
Rp5b293 p5b287 p5rb295 0.00469128
Lp5a293 p5ra294 p5a291 0.842013n
Lp5b293 p5rb295 p5b292 0.842013n
Kp5293 Lp5a293 Lp5b293 0.22195
Cp5a293 p5a291 0 0.216896p
Cp5b293 p5b292 0 0.216896p
Cp5m293 p5a291 p5b292 0.0363586p
Rp5a298 p5a291 p5ra299 0.00469128
Rp5b298 p5b292 p5rb300 0.00469128
Lp5a298 p5ra299 p5a296 0.842013n
Lp5b298 p5rb300 p5b297 0.842013n
Kp5298 Lp5a298 Lp5b298 0.22195
Cp5a298 p5a296 0 0.216896p
Cp5b298 p5b297 0 0.216896p
Cp5m298 p5a296 p5b297 0.0363586p
Rp5a301 p5a296 p5ra302 0.00469128
Rp5b301 p5b297 p5rb303 0.00469128
Lp5a301 p5ra302 dpx284 0.842013n
Lp5b301 p5rb303 dmx285 0.842013n
Kp5301 Lp5a301 Lp5b301 0.22195
Cp5a301 dpx284 0 0.216896p
Cp5b301 dmx285 0 0.216896p
Cp5m301 dpx284 dmx285 0.0363586p
Rt305 dpx284 tm304 0.00142884
Lt305 tm304 dp282 0.259609n
Ct305 dp282 0 0.0747786p
Rj306 dmx285 dm283 1m
Lv309 dp282 dp307 1.358n
Cv309 dp307 0 0.4885p
Lv310 dm283 dm308 1.358n
Cv310 dm308 0 0.4885p
Rp7a315 dp307 p7ra316 0.003075
Rp7b315 dm308 p7rb317 0.003075
Lp7a315 p7ra316 p7a313 0.551916n
Lp7b315 p7rb317 p7b314 0.551916n
Kp7315 Lp7a315 Lp7b315 0.22195
Cp7a315 p7a313 0 0.142169p
Cp7b315 p7b314 0 0.142169p
Cp7m315 p7a313 p7b314 0.023832p
Rp7a318 p7a313 p7ra319 0.003075
Rp7b318 p7b314 p7rb320 0.003075
Lp7a318 p7ra319 dpx311 0.551916n
Lp7b318 p7rb320 dmx312 0.551916n
Kp7318 Lp7a318 Lp7b318 0.22195
Cp7a318 dpx311 0 0.142169p
Cp7b318 dmx312 0 0.142169p
Cp7m318 dpx311 dmx312 0.023832p
Rt322 dpx311 tm321 0.00118725
Lt322 tm321 rp_b 0.215715n
Ct322 rp_b 0 0.0621352p
Rj323 dmx312 rm_b 1m
Cu10p conp 0 0.7p
Cu10m conm 0 0.7p
Rst327 conp stm325 0.00551383
Lst327 stm325 st326 0.74092n
Cst327 st326 0 0.137381p
Rst330 st326 stm328 0.00551383
Lst330 stm328 st329 0.74092n
Cst330 st329 0 0.137381p
Rst332 st329 stm331 0.00551383
Lst332 stm331 st324 0.74092n
Cst332 st324 0 0.137381p
Cst333 st324 0 0.3p
Rst337 conm stm335 0.00551164
Lst337 stm335 st336 0.740626n
Cst337 st336 0 0.137327p
Rst340 st336 stm338 0.00551164
Lst340 stm338 st339 0.740626n
Cst340 st339 0 0.137327p
Rst342 st339 stm341 0.00551164
Lst342 stm341 st334 0.740626n
Cst342 st334 0 0.137327p
Cst343 st334 0 0.3p
Cconp conp 0 0.6p
Cconm conm 0 0.6p
.options method=gear reltol=1e-3
.tran 0.01n 8n 0 0.02n
.control
set wr_singlescale
set wr_vecnames
set numdgt=7
run

wrdata /out/usb_delay.txt v(conp) v(conm) v(pinp) v(pinm) v(rp_b) v(rm_b)
.endc
.end
