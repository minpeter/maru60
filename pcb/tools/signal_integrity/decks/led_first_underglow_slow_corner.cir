* led_first_underglow_slow_corner: RP2350 GPIO -> SN74LV1T125 at 4.0 V -> 330R -> first LED (slow corner)
Vsrc src 0 PWL(0.0000n 0 100.0000n 0 101.5000n 3.3 400.0000n 3.3 401.5000n 0 1300.0000n 0 1301.5000n 3.3 2200.0000n 3.3 2201.5000n 0 2500.0000n 0 2501.5000n 3.3 2800.0000n 3.3 2801.5000n 0 3700.0000n 0 3701.5000n 3.3 4600.0000n 3.3 4601.5000n 0)
Rgpio src gpio 125
Cgpio gpio 0 3p
Rt3 gpio tm2 0.00316377
Lt3 tm2 p1 0.425131n
Ct3 p1 0 0.0788278p
Lv5 p1 v4 1.358n
Cv5 v4 0 0.4885p
Rt9 v4 tm7 0.00590494
Lt9 tm7 t8 0.793475n
Ct9 t8 0 0.147126p
Rt12 t8 tm10 0.00590494
Lt12 tm10 t11 0.793475n
Ct12 t11 0 0.147126p
Rt15 t11 tm13 0.00590494
Lt15 tm13 t14 0.793475n
Ct15 t14 0 0.147126p
Rt18 t14 tm16 0.00590494
Lt18 tm16 t17 0.793475n
Ct18 t17 0 0.147126p
Rt21 t17 tm19 0.00590494
Lt21 tm19 t20 0.793475n
Ct21 t20 0 0.147126p
Rt24 t20 tm22 0.00590494
Lt24 tm22 t23 0.793475n
Ct24 t23 0 0.147126p
Rt26 t23 tm25 0.00590494
Lt26 tm25 p6 0.793475n
Ct26 p6 0 0.147126p
Lv28 p6 v27 1.358n
Cv28 v27 0 0.4885p
Rt31 v27 tm30 0.00353114
Lt31 tm30 p29 0.474496n
Ct31 p29 0 0.087981p
Lv33 p29 v32 1.358n
Cv33 v32 0 0.4885p
Rt36 v32 tm35 0.0036833
Lt36 tm35 p34 0.494943n
Ct36 p34 0 0.0917724p
Lv38 p34 v37 1.358n
Cv38 v37 0 0.4885p
Rt42 v37 tm40 0.00593367
Lt42 tm40 t41 0.797337n
Ct42 t41 0 0.147842p
Rt45 t41 tm43 0.00593367
Lt45 tm43 t44 0.797337n
Ct45 t44 0 0.147842p
Rt47 t44 tm46 0.00593367
Lt47 tm46 p39 0.797337n
Ct47 p39 0 0.147842p
Lv49 p39 v48 1.358n
Cv49 v48 0 0.4885p
Rt53 v48 tm51 0.00629261
Lt53 tm51 t52 0.845569n
Ct53 t52 0 0.156785p
Rt55 t52 tm54 0.00629261
Lt55 tm54 p50 0.845569n
Ct55 p50 0 0.156785p
Lv56 p50 bufin 1.358n
Cv56 bufin 0 0.4885p
Cbufin bufin 0 10p
Bthr thr 0 V=4.0/(1+exp(-(v(bufin)-1.75)/0.03))
Rthr thr dly_in 50
Tdly dly_in 0 dly_out 0 Z0=50 TD=6.5n
Rdly dly_out 0 50
Eshp shp 0 dly_out 0 2
Rshp shp shpc 1k
Cshp shpc 0 1.364p
Ebuf bufi 0 shpc 0 1
Rbuf bufi bufout 100
Cbufout bufout 0 2.5p
Rt59 bufout tm57 0.00545439
Lt59 tm57 t58 0.732933n
Ct59 t58 0 0.1359p
Rt62 t58 tm60 0.00545439
Lt62 tm60 t61 0.732933n
Ct62 t61 0 0.1359p
Rt65 t61 tm63 0.00545439
Lt65 tm63 t64 0.732933n
Ct65 t64 0 0.1359p
Rt67 t64 tm66 0.00545439
Lt67 tm66 rin 0.732933n
Ct67 rin 0 0.1359p
R110 rin rout 330
Crpad rout 0 0.1p
Rt71 rout tm69 0.00613227
Lt71 tm69 t70 0.824023n
Ct71 t70 0 0.15279p
Rt73 t70 tm72 0.00613227
Lt73 tm72 p68 0.824023n
Ct73 p68 0 0.15279p
Lv75 p68 v74 1.358n
Cv75 v74 0 0.4885p
Rt79 v74 tm77 0.00646438
Lt79 tm77 t78 0.86865n
Ct79 t78 0 0.161065p
Rt82 t78 tm80 0.00646438
Lt82 tm80 t81 0.86865n
Ct82 t81 0 0.161065p
Rt85 t81 tm83 0.00646438
Lt85 tm83 t84 0.86865n
Ct85 t84 0 0.161065p
Rt88 t84 tm86 0.00646438
Lt88 tm86 t87 0.86865n
Ct88 t87 0 0.161065p
Rt91 t87 tm89 0.00646438
Lt91 tm89 t90 0.86865n
Ct91 t90 0 0.161065p
Rt93 t90 tm92 0.00646438
Lt93 tm92 p76 0.86865n
Ct93 p76 0 0.161065p
Lv95 p76 v94 1.358n
Cv95 v94 0 0.4885p
Rt99 v94 tm97 0.00641381
Lt99 tm97 t98 0.861855n
Ct99 t98 0 0.159805p
Rt102 t98 tm100 0.00641381
Lt102 tm100 t101 0.861855n
Ct102 t101 0 0.159805p
Rt105 t101 tm103 0.00641381
Lt105 tm103 t104 0.861855n
Ct105 t104 0 0.159805p
Rt108 t104 tm106 0.00641381
Lt108 tm106 t107 0.861855n
Ct108 t107 0 0.159805p
Rt111 t107 tm109 0.00641381
Lt111 tm109 t110 0.861855n
Ct111 t110 0 0.159805p
Rt114 t110 tm112 0.00641381
Lt114 tm112 t113 0.861855n
Ct114 t113 0 0.159805p
Rt117 t113 tm115 0.00641381
Lt117 tm115 t116 0.861855n
Ct117 t116 0 0.159805p
Rt119 t116 tm118 0.00641381
Lt119 tm118 p96 0.861855n
Ct119 p96 0 0.159805p
Lv121 p96 v120 1.358n
Cv121 v120 0 0.4885p
Rt125 v120 tm123 0.00626063
Lt125 tm123 t124 0.841271n
Ct125 t124 0 0.155988p
Rt128 t124 tm126 0.00626063
Lt128 tm126 t127 0.841271n
Ct128 t127 0 0.155988p
Rt130 t127 tm129 0.00626063
Lt130 tm129 p122 0.841271n
Ct130 p122 0 0.155988p
Lv132 p122 v131 1.358n
Cv132 v131 0 0.4885p
Rt136 v131 tm134 0.00640471
Lt136 tm134 t135 0.860631n
Ct136 t135 0 0.159578p
Rt139 t135 tm137 0.00640471
Lt139 tm137 t138 0.860631n
Ct139 t138 0 0.159578p
Rt142 t138 tm140 0.00640471
Lt142 tm140 t141 0.860631n
Ct142 t141 0 0.159578p
Rt145 t141 tm143 0.00640471
Lt145 tm143 t144 0.860631n
Ct145 t144 0 0.159578p
Rt148 t144 tm146 0.00640471
Lt148 tm146 t147 0.860631n
Ct148 t147 0 0.159578p
Rt151 t147 tm149 0.00640471
Lt151 tm149 t150 0.860631n
Ct151 t150 0 0.159578p
Rt154 t150 tm152 0.00640471
Lt154 tm152 t153 0.860631n
Ct154 t153 0 0.159578p
Rt157 t153 tm155 0.00640471
Lt157 tm155 t156 0.860631n
Ct157 t156 0 0.159578p
Rt160 t156 tm158 0.00640471
Lt160 tm158 t159 0.860631n
Ct160 t159 0 0.159578p
Rt163 t159 tm161 0.00640471
Lt163 tm161 t162 0.860631n
Ct163 t162 0 0.159578p
Rt166 t162 tm164 0.00640471
Lt166 tm164 t165 0.860631n
Ct166 t165 0 0.159578p
Rt169 t165 tm167 0.00640471
Lt169 tm167 t168 0.860631n
Ct169 t168 0 0.159578p
Rt172 t168 tm170 0.00640471
Lt172 tm170 t171 0.860631n
Ct172 t171 0 0.159578p
Rt175 t171 tm173 0.00640471
Lt175 tm173 t174 0.860631n
Ct175 t174 0 0.159578p
Rt178 t174 tm176 0.00640471
Lt178 tm176 t177 0.860631n
Ct178 t177 0 0.159578p
Rt181 t177 tm179 0.00640471
Lt181 tm179 t180 0.860631n
Ct181 t180 0 0.159578p
Rt184 t180 tm182 0.00640471
Lt184 tm182 t183 0.860631n
Ct184 t183 0 0.159578p
Rt187 t183 tm185 0.00640471
Lt187 tm185 t186 0.860631n
Ct187 t186 0 0.159578p
Rt190 t186 tm188 0.00640471
Lt190 tm188 t189 0.860631n
Ct190 t189 0 0.159578p
Rt193 t189 tm191 0.00640471
Lt193 tm191 t192 0.860631n
Ct193 t192 0 0.159578p
Rt196 t192 tm194 0.00640471
Lt196 tm194 t195 0.860631n
Ct196 t195 0 0.159578p
Rt199 t195 tm197 0.00640471
Lt199 tm197 t198 0.860631n
Ct199 t198 0 0.159578p
Rt202 t198 tm200 0.00640471
Lt202 tm200 t201 0.860631n
Ct202 t201 0 0.159578p
Rt205 t201 tm203 0.00640471
Lt205 tm203 t204 0.860631n
Ct205 t204 0 0.159578p
Rt208 t204 tm206 0.00640471
Lt208 tm206 t207 0.860631n
Ct208 t207 0 0.159578p
Rt211 t207 tm209 0.00640471
Lt211 tm209 t210 0.860631n
Ct211 t210 0 0.159578p
Rt214 t210 tm212 0.00640471
Lt214 tm212 t213 0.860631n
Ct214 t213 0 0.159578p
Rt217 t213 tm215 0.00640471
Lt217 tm215 t216 0.860631n
Ct217 t216 0 0.159578p
Rt220 t216 tm218 0.00640471
Lt220 tm218 t219 0.860631n
Ct220 t219 0 0.159578p
Rt223 t219 tm221 0.00640471
Lt223 tm221 t222 0.860631n
Ct223 t222 0 0.159578p
Rt225 t222 tm224 0.00640471
Lt225 tm224 p133 0.860631n
Ct225 p133 0 0.159578p
Lv227 p133 v226 1.358n
Cv227 v226 0 0.4885p
Rt230 v226 tm229 0.00376762
Lt230 tm229 p228 0.506273n
Ct230 p228 0 0.0938732p
Lv232 p228 v231 1.358n
Cv232 v231 0 0.4885p
Rt236 v231 tm234 0.00583126
Lt236 tm234 t235 0.783575n
Ct236 t235 0 0.14529p
Rt239 t235 tm237 0.00583126
Lt239 tm237 t238 0.783575n
Ct239 t238 0 0.14529p
Rt242 t238 tm240 0.00583126
Lt242 tm240 t241 0.783575n
Ct242 t241 0 0.14529p
Rt245 t241 tm243 0.00583126
Lt245 tm243 t244 0.783575n
Ct245 t244 0 0.14529p
Rt248 t244 tm246 0.00583126
Lt248 tm246 t247 0.783575n
Ct248 t247 0 0.14529p
Rt250 t247 tm249 0.00583126
Lt250 tm249 p233 0.783575n
Ct250 p233 0 0.14529p
Lv252 p233 v251 1.358n
Cv252 v251 0 0.4885p
Rt256 v251 tm254 0.00591822
Lt256 tm254 t255 0.79526n
Ct256 t255 0 0.147457p
Rt259 t255 tm257 0.00591822
Lt259 tm257 t258 0.79526n
Ct259 t258 0 0.147457p
Rt261 t258 tm260 0.00591822
Lt261 tm260 p253 0.79526n
Ct261 p253 0 0.147457p
Lv263 p253 v262 1.358n
Cv263 v262 0 0.4885p
Rt265 v262 tm264 0.00398282
Lt265 tm264 din 0.53519n
Ct265 din 0 0.099235p
Cin din 0 15p
.tran 0.1n 5000n 0 0.2n
.control
set wr_singlescale
set wr_vecnames
set numdgt=7
run

wrdata /out/led_first_underglow_slow_corner.txt v(gpio) v(bufin) v(bufout) v(din)
.endc
.end
