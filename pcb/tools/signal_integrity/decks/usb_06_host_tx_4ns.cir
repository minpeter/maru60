* USB full speed, host_tx, source ramp 4 ns, cable 1 m
Rrxp pinp 0 10meg
Rrxm pinm 0 10meg
Cpinp pinp 0 5p
Cpinm pinm 0 5p
Vpu vpu 0 3.3
Rpu vpu pinp 1.5k
Rt3 pinp tm1 0.00448183
Lt3 tm1 t2 0.602245n
Ct3 t2 0 0.111668p
Rt6 t2 tm4 0.00448183
Lt6 tm4 t5 0.602245n
Ct6 t5 0 0.111668p
Rt8 t5 tm7 0.00448183
Lt8 tm7 rp_a 0.602245n
Ct8 rp_a 0 0.111668p
Rt11 pinm tm9 0.00625752
Lt11 tm9 t10 0.840854n
Ct11 t10 0 0.155911p
Rt13 t10 tm12 0.00625752
Lt13 tm12 rm_a 0.840854n
Ct13 rm_a 0 0.155911p
R102 rp_a rp_b 27
R103 rm_a rm_b 27
Rt18 conp tm17 0.0030141
Lt18 tm17 u16 0.405019n
Ct18 u16 0 0.0750985p
Lv20 u16 u19 1.358n
Cv20 u19 0 0.4885p
Rt23 u19 tm21 0.00562666
Lt23 tm21 t22 0.756081n
Ct23 t22 0 0.140193p
Rt26 t22 tm24 0.00562666
Lt26 tm24 t25 0.756081n
Ct26 t25 0 0.140193p
Rt28 t25 tm27 0.00562666
Lt28 tm27 dp14 0.756081n
Ct28 dp14 0 0.140193p
Rt31 conm tm30 0.00582544
Lt31 tm30 u29 0.782792n
Ct31 u29 0 0.145145p
Lv33 u29 u32 1.358n
Cv33 u32 0 0.4885p
Rt36 u32 tm34 0.00468437
Lt36 tm34 t35 0.629461n
Ct36 t35 0 0.116715p
Rt39 t35 tm37 0.00468437
Lt39 tm37 t38 0.629461n
Ct39 t38 0 0.116715p
Rt41 t38 tm40 0.00468437
Lt41 tm40 dm15 0.629461n
Ct41 dm15 0 0.116715p
Rp1a48 dp14 p1ra49 0.00578857
Rp1b48 dm15 p1rb50 0.00578857
Lp1a48 p1ra49 p1a46 1.03896n
Lp1b48 p1rb50 p1b47 1.03896n
Kp148 Lp1a48 Lp1b48 0.22195
Cp1a48 p1a46 0 0.267628p
Cp1b48 p1b47 0 0.267628p
Cp1m48 p1a46 p1b47 0.0448628p
Rp1a53 p1a46 p1ra54 0.00578857
Rp1b53 p1b47 p1rb55 0.00578857
Lp1a53 p1ra54 p1a51 1.03896n
Lp1b53 p1rb55 p1b52 1.03896n
Kp153 Lp1a53 Lp1b53 0.22195
Cp1a53 p1a51 0 0.267628p
Cp1b53 p1b52 0 0.267628p
Cp1m53 p1a51 p1b52 0.0448628p
Rp1a58 p1a51 p1ra59 0.00578857
Rp1b58 p1b52 p1rb60 0.00578857
Lp1a58 p1ra59 p1a56 1.03896n
Lp1b58 p1rb60 p1b57 1.03896n
Kp158 Lp1a58 Lp1b58 0.22195
Cp1a58 p1a56 0 0.267628p
Cp1b58 p1b57 0 0.267628p
Cp1m58 p1a56 p1b57 0.0448628p
Rp1a63 p1a56 p1ra64 0.00578857
Rp1b63 p1b57 p1rb65 0.00578857
Lp1a63 p1ra64 p1a61 1.03896n
Lp1b63 p1rb65 p1b62 1.03896n
Kp163 Lp1a63 Lp1b63 0.22195
Cp1a63 p1a61 0 0.267628p
Cp1b63 p1b62 0 0.267628p
Cp1m63 p1a61 p1b62 0.0448628p
Rp1a68 p1a61 p1ra69 0.00578857
Rp1b68 p1b62 p1rb70 0.00578857
Lp1a68 p1ra69 p1a66 1.03896n
Lp1b68 p1rb70 p1b67 1.03896n
Kp168 Lp1a68 Lp1b68 0.22195
Cp1a68 p1a66 0 0.267628p
Cp1b68 p1b67 0 0.267628p
Cp1m68 p1a66 p1b67 0.0448628p
Rp1a73 p1a66 p1ra74 0.00578857
Rp1b73 p1b67 p1rb75 0.00578857
Lp1a73 p1ra74 p1a71 1.03896n
Lp1b73 p1rb75 p1b72 1.03896n
Kp173 Lp1a73 Lp1b73 0.22195
Cp1a73 p1a71 0 0.267628p
Cp1b73 p1b72 0 0.267628p
Cp1m73 p1a71 p1b72 0.0448628p
Rp1a78 p1a71 p1ra79 0.00578857
Rp1b78 p1b72 p1rb80 0.00578857
Lp1a78 p1ra79 p1a76 1.03896n
Lp1b78 p1rb80 p1b77 1.03896n
Kp178 Lp1a78 Lp1b78 0.22195
Cp1a78 p1a76 0 0.267628p
Cp1b78 p1b77 0 0.267628p
Cp1m78 p1a76 p1b77 0.0448628p
Rp1a83 p1a76 p1ra84 0.00578857
Rp1b83 p1b77 p1rb85 0.00578857
Lp1a83 p1ra84 p1a81 1.03896n
Lp1b83 p1rb85 p1b82 1.03896n
Kp183 Lp1a83 Lp1b83 0.22195
Cp1a83 p1a81 0 0.267628p
Cp1b83 p1b82 0 0.267628p
Cp1m83 p1a81 p1b82 0.0448628p
Rp1a88 p1a81 p1ra89 0.00578857
Rp1b88 p1b82 p1rb90 0.00578857
Lp1a88 p1ra89 p1a86 1.03896n
Lp1b88 p1rb90 p1b87 1.03896n
Kp188 Lp1a88 Lp1b88 0.22195
Cp1a88 p1a86 0 0.267628p
Cp1b88 p1b87 0 0.267628p
Cp1m88 p1a86 p1b87 0.0448628p
Rp1a93 p1a86 p1ra94 0.00578857
Rp1b93 p1b87 p1rb95 0.00578857
Lp1a93 p1ra94 p1a91 1.03896n
Lp1b93 p1rb95 p1b92 1.03896n
Kp193 Lp1a93 Lp1b93 0.22195
Cp1a93 p1a91 0 0.267628p
Cp1b93 p1b92 0 0.267628p
Cp1m93 p1a91 p1b92 0.0448628p
Rp1a98 p1a91 p1ra99 0.00578857
Rp1b98 p1b92 p1rb100 0.00578857
Lp1a98 p1ra99 p1a96 1.03896n
Lp1b98 p1rb100 p1b97 1.03896n
Kp198 Lp1a98 Lp1b98 0.22195
Cp1a98 p1a96 0 0.267628p
Cp1b98 p1b97 0 0.267628p
Cp1m98 p1a96 p1b97 0.0448628p
Rp1a103 p1a96 p1ra104 0.00578857
Rp1b103 p1b97 p1rb105 0.00578857
Lp1a103 p1ra104 p1a101 1.03896n
Lp1b103 p1rb105 p1b102 1.03896n
Kp1103 Lp1a103 Lp1b103 0.22195
Cp1a103 p1a101 0 0.267628p
Cp1b103 p1b102 0 0.267628p
Cp1m103 p1a101 p1b102 0.0448628p
Rp1a106 p1a101 p1ra107 0.00578857
Rp1b106 p1b102 p1rb108 0.00578857
Lp1a106 p1ra107 dpx44 1.03896n
Lp1b106 p1rb108 dmx45 1.03896n
Kp1106 Lp1a106 Lp1b106 0.22195
Cp1a106 dpx44 0 0.267628p
Cp1b106 dmx45 0 0.267628p
Cp1m106 dpx44 dmx45 0.0448628p
Rt110 dpx44 tm109 9.08444e-06
Lt110 tm109 dp42 0.00165058n
Ct110 dp42 0 0.000475437p
Rj111 dmx45 dm43 1m
Lv114 dp42 dp112 1.358n
Cv114 dp112 0 0.4885p
Lv115 dm43 dm113 1.358n
Cv115 dm113 0 0.4885p
Rp3a122 dp112 p3ra123 0.0057538
Rp3b122 dm113 p3rb124 0.0057538
Lp3a122 p3ra123 p3a120 1.03272n
Lp3b122 p3rb124 p3b121 1.03272n
Kp3122 Lp3a122 Lp3b122 0.22195
Cp3a122 p3a120 0 0.26602p
Cp3b122 p3b121 0 0.26602p
Cp3m122 p3a120 p3b121 0.0445933p
Rp3a127 p3a120 p3ra128 0.0057538
Rp3b127 p3b121 p3rb129 0.0057538
Lp3a127 p3ra128 p3a125 1.03272n
Lp3b127 p3rb129 p3b126 1.03272n
Kp3127 Lp3a127 Lp3b127 0.22195
Cp3a127 p3a125 0 0.26602p
Cp3b127 p3b126 0 0.26602p
Cp3m127 p3a125 p3b126 0.0445933p
Rp3a132 p3a125 p3ra133 0.0057538
Rp3b132 p3b126 p3rb134 0.0057538
Lp3a132 p3ra133 p3a130 1.03272n
Lp3b132 p3rb134 p3b131 1.03272n
Kp3132 Lp3a132 Lp3b132 0.22195
Cp3a132 p3a130 0 0.26602p
Cp3b132 p3b131 0 0.26602p
Cp3m132 p3a130 p3b131 0.0445933p
Rp3a137 p3a130 p3ra138 0.0057538
Rp3b137 p3b131 p3rb139 0.0057538
Lp3a137 p3ra138 p3a135 1.03272n
Lp3b137 p3rb139 p3b136 1.03272n
Kp3137 Lp3a137 Lp3b137 0.22195
Cp3a137 p3a135 0 0.26602p
Cp3b137 p3b136 0 0.26602p
Cp3m137 p3a135 p3b136 0.0445933p
Rp3a142 p3a135 p3ra143 0.0057538
Rp3b142 p3b136 p3rb144 0.0057538
Lp3a142 p3ra143 p3a140 1.03272n
Lp3b142 p3rb144 p3b141 1.03272n
Kp3142 Lp3a142 Lp3b142 0.22195
Cp3a142 p3a140 0 0.26602p
Cp3b142 p3b141 0 0.26602p
Cp3m142 p3a140 p3b141 0.0445933p
Rp3a147 p3a140 p3ra148 0.0057538
Rp3b147 p3b141 p3rb149 0.0057538
Lp3a147 p3ra148 p3a145 1.03272n
Lp3b147 p3rb149 p3b146 1.03272n
Kp3147 Lp3a147 Lp3b147 0.22195
Cp3a147 p3a145 0 0.26602p
Cp3b147 p3b146 0 0.26602p
Cp3m147 p3a145 p3b146 0.0445933p
Rp3a152 p3a145 p3ra153 0.0057538
Rp3b152 p3b146 p3rb154 0.0057538
Lp3a152 p3ra153 p3a150 1.03272n
Lp3b152 p3rb154 p3b151 1.03272n
Kp3152 Lp3a152 Lp3b152 0.22195
Cp3a152 p3a150 0 0.26602p
Cp3b152 p3b151 0 0.26602p
Cp3m152 p3a150 p3b151 0.0445933p
Rp3a157 p3a150 p3ra158 0.0057538
Rp3b157 p3b151 p3rb159 0.0057538
Lp3a157 p3ra158 p3a155 1.03272n
Lp3b157 p3rb159 p3b156 1.03272n
Kp3157 Lp3a157 Lp3b157 0.22195
Cp3a157 p3a155 0 0.26602p
Cp3b157 p3b156 0 0.26602p
Cp3m157 p3a155 p3b156 0.0445933p
Rp3a162 p3a155 p3ra163 0.0057538
Rp3b162 p3b156 p3rb164 0.0057538
Lp3a162 p3ra163 p3a160 1.03272n
Lp3b162 p3rb164 p3b161 1.03272n
Kp3162 Lp3a162 Lp3b162 0.22195
Cp3a162 p3a160 0 0.26602p
Cp3b162 p3b161 0 0.26602p
Cp3m162 p3a160 p3b161 0.0445933p
Rp3a167 p3a160 p3ra168 0.0057538
Rp3b167 p3b161 p3rb169 0.0057538
Lp3a167 p3ra168 p3a165 1.03272n
Lp3b167 p3rb169 p3b166 1.03272n
Kp3167 Lp3a167 Lp3b167 0.22195
Cp3a167 p3a165 0 0.26602p
Cp3b167 p3b166 0 0.26602p
Cp3m167 p3a165 p3b166 0.0445933p
Rp3a172 p3a165 p3ra173 0.0057538
Rp3b172 p3b166 p3rb174 0.0057538
Lp3a172 p3ra173 p3a170 1.03272n
Lp3b172 p3rb174 p3b171 1.03272n
Kp3172 Lp3a172 Lp3b172 0.22195
Cp3a172 p3a170 0 0.26602p
Cp3b172 p3b171 0 0.26602p
Cp3m172 p3a170 p3b171 0.0445933p
Rp3a177 p3a170 p3ra178 0.0057538
Rp3b177 p3b171 p3rb179 0.0057538
Lp3a177 p3ra178 p3a175 1.03272n
Lp3b177 p3rb179 p3b176 1.03272n
Kp3177 Lp3a177 Lp3b177 0.22195
Cp3a177 p3a175 0 0.26602p
Cp3b177 p3b176 0 0.26602p
Cp3m177 p3a175 p3b176 0.0445933p
Rp3a182 p3a175 p3ra183 0.0057538
Rp3b182 p3b176 p3rb184 0.0057538
Lp3a182 p3ra183 p3a180 1.03272n
Lp3b182 p3rb184 p3b181 1.03272n
Kp3182 Lp3a182 Lp3b182 0.22195
Cp3a182 p3a180 0 0.26602p
Cp3b182 p3b181 0 0.26602p
Cp3m182 p3a180 p3b181 0.0445933p
Rp3a187 p3a180 p3ra188 0.0057538
Rp3b187 p3b181 p3rb189 0.0057538
Lp3a187 p3ra188 p3a185 1.03272n
Lp3b187 p3rb189 p3b186 1.03272n
Kp3187 Lp3a187 Lp3b187 0.22195
Cp3a187 p3a185 0 0.26602p
Cp3b187 p3b186 0 0.26602p
Cp3m187 p3a185 p3b186 0.0445933p
Rp3a192 p3a185 p3ra193 0.0057538
Rp3b192 p3b186 p3rb194 0.0057538
Lp3a192 p3ra193 p3a190 1.03272n
Lp3b192 p3rb194 p3b191 1.03272n
Kp3192 Lp3a192 Lp3b192 0.22195
Cp3a192 p3a190 0 0.26602p
Cp3b192 p3b191 0 0.26602p
Cp3m192 p3a190 p3b191 0.0445933p
Rp3a197 p3a190 p3ra198 0.0057538
Rp3b197 p3b191 p3rb199 0.0057538
Lp3a197 p3ra198 p3a195 1.03272n
Lp3b197 p3rb199 p3b196 1.03272n
Kp3197 Lp3a197 Lp3b197 0.22195
Cp3a197 p3a195 0 0.26602p
Cp3b197 p3b196 0 0.26602p
Cp3m197 p3a195 p3b196 0.0445933p
Rp3a202 p3a195 p3ra203 0.0057538
Rp3b202 p3b196 p3rb204 0.0057538
Lp3a202 p3ra203 p3a200 1.03272n
Lp3b202 p3rb204 p3b201 1.03272n
Kp3202 Lp3a202 Lp3b202 0.22195
Cp3a202 p3a200 0 0.26602p
Cp3b202 p3b201 0 0.26602p
Cp3m202 p3a200 p3b201 0.0445933p
Rp3a207 p3a200 p3ra208 0.0057538
Rp3b207 p3b201 p3rb209 0.0057538
Lp3a207 p3ra208 p3a205 1.03272n
Lp3b207 p3rb209 p3b206 1.03272n
Kp3207 Lp3a207 Lp3b207 0.22195
Cp3a207 p3a205 0 0.26602p
Cp3b207 p3b206 0 0.26602p
Cp3m207 p3a205 p3b206 0.0445933p
Rp3a212 p3a205 p3ra213 0.0057538
Rp3b212 p3b206 p3rb214 0.0057538
Lp3a212 p3ra213 p3a210 1.03272n
Lp3b212 p3rb214 p3b211 1.03272n
Kp3212 Lp3a212 Lp3b212 0.22195
Cp3a212 p3a210 0 0.26602p
Cp3b212 p3b211 0 0.26602p
Cp3m212 p3a210 p3b211 0.0445933p
Rp3a217 p3a210 p3ra218 0.0057538
Rp3b217 p3b211 p3rb219 0.0057538
Lp3a217 p3ra218 p3a215 1.03272n
Lp3b217 p3rb219 p3b216 1.03272n
Kp3217 Lp3a217 Lp3b217 0.22195
Cp3a217 p3a215 0 0.26602p
Cp3b217 p3b216 0 0.26602p
Cp3m217 p3a215 p3b216 0.0445933p
Rp3a222 p3a215 p3ra223 0.0057538
Rp3b222 p3b216 p3rb224 0.0057538
Lp3a222 p3ra223 p3a220 1.03272n
Lp3b222 p3rb224 p3b221 1.03272n
Kp3222 Lp3a222 Lp3b222 0.22195
Cp3a222 p3a220 0 0.26602p
Cp3b222 p3b221 0 0.26602p
Cp3m222 p3a220 p3b221 0.0445933p
Rp3a227 p3a220 p3ra228 0.0057538
Rp3b227 p3b221 p3rb229 0.0057538
Lp3a227 p3ra228 p3a225 1.03272n
Lp3b227 p3rb229 p3b226 1.03272n
Kp3227 Lp3a227 Lp3b227 0.22195
Cp3a227 p3a225 0 0.26602p
Cp3b227 p3b226 0 0.26602p
Cp3m227 p3a225 p3b226 0.0445933p
Rp3a232 p3a225 p3ra233 0.0057538
Rp3b232 p3b226 p3rb234 0.0057538
Lp3a232 p3ra233 p3a230 1.03272n
Lp3b232 p3rb234 p3b231 1.03272n
Kp3232 Lp3a232 Lp3b232 0.22195
Cp3a232 p3a230 0 0.26602p
Cp3b232 p3b231 0 0.26602p
Cp3m232 p3a230 p3b231 0.0445933p
Rp3a237 p3a230 p3ra238 0.0057538
Rp3b237 p3b231 p3rb239 0.0057538
Lp3a237 p3ra238 p3a235 1.03272n
Lp3b237 p3rb239 p3b236 1.03272n
Kp3237 Lp3a237 Lp3b237 0.22195
Cp3a237 p3a235 0 0.26602p
Cp3b237 p3b236 0 0.26602p
Cp3m237 p3a235 p3b236 0.0445933p
Rp3a242 p3a235 p3ra243 0.0057538
Rp3b242 p3b236 p3rb244 0.0057538
Lp3a242 p3ra243 p3a240 1.03272n
Lp3b242 p3rb244 p3b241 1.03272n
Kp3242 Lp3a242 Lp3b242 0.22195
Cp3a242 p3a240 0 0.26602p
Cp3b242 p3b241 0 0.26602p
Cp3m242 p3a240 p3b241 0.0445933p
Rp3a245 p3a240 p3ra246 0.0057538
Rp3b245 p3b241 p3rb247 0.0057538
Lp3a245 p3ra246 dpx118 1.03272n
Lp3b245 p3rb247 dmx119 1.03272n
Kp3245 Lp3a245 Lp3b245 0.22195
Cp3a245 dpx118 0 0.26602p
Cp3b245 dmx119 0 0.26602p
Cp3m245 dpx118 dmx119 0.0445933p
Rj248 dpx118 dp116 1m
Rt250 dmx119 tm249 3.33044e-05
Lt250 tm249 dm117 0.00605117n
Ct250 dm117 0 0.00174299p
Rt255 dp116 tm254 0.00643789
Lt255 tm254 u253 0.86509n
Ct255 u253 0 0.160405p
Lv257 u253 u256 1.358n
Cv257 u256 0 0.4885p
Rt260 u256 tm258 0.0033742
Lt260 tm258 t259 0.453408n
Ct260 t259 0 0.0840709p
Rt262 t259 tm261 0.0033742
Lt262 tm261 dp251 0.453408n
Ct262 dp251 0 0.0840709p
Rt265 dm117 tm264 0.00628268
Lt265 tm264 u263 0.844235n
Ct265 u263 0 0.156538p
Lv267 u263 u266 1.358n
Cv267 u266 0 0.4885p
Rt269 u266 tm268 0.00627529
Lt269 tm268 dm252 0.843241n
Ct269 dm252 0 0.156354p
Rp5a276 dp251 p5ra277 0.00469128
Rp5b276 dm252 p5rb278 0.00469128
Lp5a276 p5ra277 p5a274 0.842013n
Lp5b276 p5rb278 p5b275 0.842013n
Kp5276 Lp5a276 Lp5b276 0.22195
Cp5a276 p5a274 0 0.216896p
Cp5b276 p5b275 0 0.216896p
Cp5m276 p5a274 p5b275 0.0363586p
Rp5a281 p5a274 p5ra282 0.00469128
Rp5b281 p5b275 p5rb283 0.00469128
Lp5a281 p5ra282 p5a279 0.842013n
Lp5b281 p5rb283 p5b280 0.842013n
Kp5281 Lp5a281 Lp5b281 0.22195
Cp5a281 p5a279 0 0.216896p
Cp5b281 p5b280 0 0.216896p
Cp5m281 p5a279 p5b280 0.0363586p
Rp5a286 p5a279 p5ra287 0.00469128
Rp5b286 p5b280 p5rb288 0.00469128
Lp5a286 p5ra287 p5a284 0.842013n
Lp5b286 p5rb288 p5b285 0.842013n
Kp5286 Lp5a286 Lp5b286 0.22195
Cp5a286 p5a284 0 0.216896p
Cp5b286 p5b285 0 0.216896p
Cp5m286 p5a284 p5b285 0.0363586p
Rp5a289 p5a284 p5ra290 0.00469128
Rp5b289 p5b285 p5rb291 0.00469128
Lp5a289 p5ra290 dpx272 0.842013n
Lp5b289 p5rb291 dmx273 0.842013n
Kp5289 Lp5a289 Lp5b289 0.22195
Cp5a289 dpx272 0 0.216896p
Cp5b289 dmx273 0 0.216896p
Cp5m289 dpx272 dmx273 0.0363586p
Rt293 dpx272 tm292 0.00142884
Lt293 tm292 dp270 0.259609n
Ct293 dp270 0 0.0747786p
Rj294 dmx273 dm271 1m
Lv297 dp270 dp295 1.358n
Cv297 dp295 0 0.4885p
Lv298 dm271 dm296 1.358n
Cv298 dm296 0 0.4885p
Rp7a303 dp295 p7ra304 0.003075
Rp7b303 dm296 p7rb305 0.003075
Lp7a303 p7ra304 p7a301 0.551916n
Lp7b303 p7rb305 p7b302 0.551916n
Kp7303 Lp7a303 Lp7b303 0.22195
Cp7a303 p7a301 0 0.142169p
Cp7b303 p7b302 0 0.142169p
Cp7m303 p7a301 p7b302 0.023832p
Rp7a306 p7a301 p7ra307 0.003075
Rp7b306 p7b302 p7rb308 0.003075
Lp7a306 p7ra307 dpx299 0.551916n
Lp7b306 p7rb308 dmx300 0.551916n
Kp7306 Lp7a306 Lp7b306 0.22195
Cp7a306 dpx299 0 0.142169p
Cp7b306 dmx300 0 0.142169p
Cp7m306 dpx299 dmx300 0.023832p
Rt310 dpx299 tm309 0.00118725
Lt310 tm309 rp_b 0.215715n
Ct310 rp_b 0 0.0621352p
Rj311 dmx300 rm_b 1m
Cu10p conp 0 0.7p
Cu10m conm 0 0.7p
Rst315 conp stm313 0.00551383
Lst315 stm313 st314 0.74092n
Cst315 st314 0 0.137381p
Rst318 st314 stm316 0.00551383
Lst318 stm316 st317 0.74092n
Cst318 st317 0 0.137381p
Rst320 st317 stm319 0.00551383
Lst320 stm319 st312 0.74092n
Cst320 st312 0 0.137381p
Cst321 st312 0 0.3p
Rst325 conm stm323 0.00551164
Lst325 stm323 st324 0.740626n
Cst325 st324 0 0.137327p
Rst328 st324 stm326 0.00551164
Lst328 stm326 st327 0.740626n
Cst328 st327 0 0.137327p
Rst330 st327 stm329 0.00551164
Lst330 stm329 st322 0.740626n
Cst330 st322 0 0.137327p
Cst331 st322 0 0.3p
Cconp conp 0 0.6p
Cconm conm 0 0.6p
Rcbp0 conp cb332 4.6m
Lcbp0 cb332 cb333 4.68n
Ccbp0 cb333 0 2.3111p
Rcbp1 cb333 cb334 4.6m
Lcbp1 cb334 cb335 4.68n
Ccbp1 cb335 0 2.3111p
Rcbp2 cb335 cb336 4.6m
Lcbp2 cb336 cb337 4.68n
Ccbp2 cb337 0 2.3111p
Rcbp3 cb337 cb338 4.6m
Lcbp3 cb338 cb339 4.68n
Ccbp3 cb339 0 2.3111p
Rcbp4 cb339 cb340 4.6m
Lcbp4 cb340 cb341 4.68n
Ccbp4 cb341 0 2.3111p
Rcbp5 cb341 cb342 4.6m
Lcbp5 cb342 cb343 4.68n
Ccbp5 cb343 0 2.3111p
Rcbp6 cb343 cb344 4.6m
Lcbp6 cb344 cb345 4.68n
Ccbp6 cb345 0 2.3111p
Rcbp7 cb345 cb346 4.6m
Lcbp7 cb346 cb347 4.68n
Ccbp7 cb347 0 2.3111p
Rcbp8 cb347 cb348 4.6m
Lcbp8 cb348 cb349 4.68n
Ccbp8 cb349 0 2.3111p
Rcbp9 cb349 cb350 4.6m
Lcbp9 cb350 cb351 4.68n
Ccbp9 cb351 0 2.3111p
Rcbp10 cb351 cb352 4.6m
Lcbp10 cb352 cb353 4.68n
Ccbp10 cb353 0 2.3111p
Rcbp11 cb353 cb354 4.6m
Lcbp11 cb354 cb355 4.68n
Ccbp11 cb355 0 2.3111p
Rcbp12 cb355 cb356 4.6m
Lcbp12 cb356 cb357 4.68n
Ccbp12 cb357 0 2.3111p
Rcbp13 cb357 cb358 4.6m
Lcbp13 cb358 cb359 4.68n
Ccbp13 cb359 0 2.3111p
Rcbp14 cb359 cb360 4.6m
Lcbp14 cb360 cb361 4.68n
Ccbp14 cb361 0 2.3111p
Rcbp15 cb361 cb362 4.6m
Lcbp15 cb362 cb363 4.68n
Ccbp15 cb363 0 2.3111p
Rcbp16 cb363 cb364 4.6m
Lcbp16 cb364 cb365 4.68n
Ccbp16 cb365 0 2.3111p
Rcbp17 cb365 cb366 4.6m
Lcbp17 cb366 cb367 4.68n
Ccbp17 cb367 0 2.3111p
Rcbp18 cb367 cb368 4.6m
Lcbp18 cb368 cb369 4.68n
Ccbp18 cb369 0 2.3111p
Rcbp19 cb369 cb370 4.6m
Lcbp19 cb370 cb371 4.68n
Ccbp19 cb371 0 2.3111p
Rcbp20 cb371 cb372 4.6m
Lcbp20 cb372 cb373 4.68n
Ccbp20 cb373 0 2.3111p
Rcbp21 cb373 cb374 4.6m
Lcbp21 cb374 cb375 4.68n
Ccbp21 cb375 0 2.3111p
Rcbp22 cb375 cb376 4.6m
Lcbp22 cb376 cb377 4.68n
Ccbp22 cb377 0 2.3111p
Rcbp23 cb377 cb378 4.6m
Lcbp23 cb378 cb379 4.68n
Ccbp23 cb379 0 2.3111p
Rcbp24 cb379 cb380 4.6m
Lcbp24 cb380 cb381 4.68n
Ccbp24 cb381 0 2.3111p
Rcbp25 cb381 cb382 4.6m
Lcbp25 cb382 cb383 4.68n
Ccbp25 cb383 0 2.3111p
Rcbp26 cb383 cb384 4.6m
Lcbp26 cb384 cb385 4.68n
Ccbp26 cb385 0 2.3111p
Rcbp27 cb385 cb386 4.6m
Lcbp27 cb386 cb387 4.68n
Ccbp27 cb387 0 2.3111p
Rcbp28 cb387 cb388 4.6m
Lcbp28 cb388 cb389 4.68n
Ccbp28 cb389 0 2.3111p
Rcbp29 cb389 cb390 4.6m
Lcbp29 cb390 cb391 4.68n
Ccbp29 cb391 0 2.3111p
Rcbp30 cb391 cb392 4.6m
Lcbp30 cb392 cb393 4.68n
Ccbp30 cb393 0 2.3111p
Rcbp31 cb393 cb394 4.6m
Lcbp31 cb394 cb395 4.68n
Ccbp31 cb395 0 2.3111p
Rcbp32 cb395 cb396 4.6m
Lcbp32 cb396 cb397 4.68n
Ccbp32 cb397 0 2.3111p
Rcbp33 cb397 cb398 4.6m
Lcbp33 cb398 cb399 4.68n
Ccbp33 cb399 0 2.3111p
Rcbp34 cb399 cb400 4.6m
Lcbp34 cb400 cb401 4.68n
Ccbp34 cb401 0 2.3111p
Rcbp35 cb401 cb402 4.6m
Lcbp35 cb402 cb403 4.68n
Ccbp35 cb403 0 2.3111p
Rcbp36 cb403 cb404 4.6m
Lcbp36 cb404 cb405 4.68n
Ccbp36 cb405 0 2.3111p
Rcbp37 cb405 cb406 4.6m
Lcbp37 cb406 cb407 4.68n
Ccbp37 cb407 0 2.3111p
Rcbp38 cb407 cb408 4.6m
Lcbp38 cb408 cb409 4.68n
Ccbp38 cb409 0 2.3111p
Rcbp39 cb409 cb410 4.6m
Lcbp39 cb410 cb411 4.68n
Ccbp39 cb411 0 2.3111p
Rcbp40 cb411 cb412 4.6m
Lcbp40 cb412 cb413 4.68n
Ccbp40 cb413 0 2.3111p
Rcbp41 cb413 cb414 4.6m
Lcbp41 cb414 cb415 4.68n
Ccbp41 cb415 0 2.3111p
Rcbp42 cb415 cb416 4.6m
Lcbp42 cb416 cb417 4.68n
Ccbp42 cb417 0 2.3111p
Rcbp43 cb417 cb418 4.6m
Lcbp43 cb418 cb419 4.68n
Ccbp43 cb419 0 2.3111p
Rcbp44 cb419 cb420 4.6m
Lcbp44 cb420 cb421 4.68n
Ccbp44 cb421 0 2.3111p
Rcbp45 cb421 cb422 4.6m
Lcbp45 cb422 cb423 4.68n
Ccbp45 cb423 0 2.3111p
Rcbp46 cb423 cb424 4.6m
Lcbp46 cb424 cb425 4.68n
Ccbp46 cb425 0 2.3111p
Rcbp47 cb425 cb426 4.6m
Lcbp47 cb426 cb427 4.68n
Ccbp47 cb427 0 2.3111p
Rcbp48 cb427 cb428 4.6m
Lcbp48 cb428 cb429 4.68n
Ccbp48 cb429 0 2.3111p
Rcbp49 cb429 cb430 4.6m
Lcbp49 cb430 hp 4.68n
Ccbp49 hp 0 2.3111p
Rcbm0 conm cb431 4.6m
Lcbm0 cb431 cb432 4.68n
Ccbm0 cb432 0 2.3111p
Rcbm1 cb432 cb433 4.6m
Lcbm1 cb433 cb434 4.68n
Ccbm1 cb434 0 2.3111p
Rcbm2 cb434 cb435 4.6m
Lcbm2 cb435 cb436 4.68n
Ccbm2 cb436 0 2.3111p
Rcbm3 cb436 cb437 4.6m
Lcbm3 cb437 cb438 4.68n
Ccbm3 cb438 0 2.3111p
Rcbm4 cb438 cb439 4.6m
Lcbm4 cb439 cb440 4.68n
Ccbm4 cb440 0 2.3111p
Rcbm5 cb440 cb441 4.6m
Lcbm5 cb441 cb442 4.68n
Ccbm5 cb442 0 2.3111p
Rcbm6 cb442 cb443 4.6m
Lcbm6 cb443 cb444 4.68n
Ccbm6 cb444 0 2.3111p
Rcbm7 cb444 cb445 4.6m
Lcbm7 cb445 cb446 4.68n
Ccbm7 cb446 0 2.3111p
Rcbm8 cb446 cb447 4.6m
Lcbm8 cb447 cb448 4.68n
Ccbm8 cb448 0 2.3111p
Rcbm9 cb448 cb449 4.6m
Lcbm9 cb449 cb450 4.68n
Ccbm9 cb450 0 2.3111p
Rcbm10 cb450 cb451 4.6m
Lcbm10 cb451 cb452 4.68n
Ccbm10 cb452 0 2.3111p
Rcbm11 cb452 cb453 4.6m
Lcbm11 cb453 cb454 4.68n
Ccbm11 cb454 0 2.3111p
Rcbm12 cb454 cb455 4.6m
Lcbm12 cb455 cb456 4.68n
Ccbm12 cb456 0 2.3111p
Rcbm13 cb456 cb457 4.6m
Lcbm13 cb457 cb458 4.68n
Ccbm13 cb458 0 2.3111p
Rcbm14 cb458 cb459 4.6m
Lcbm14 cb459 cb460 4.68n
Ccbm14 cb460 0 2.3111p
Rcbm15 cb460 cb461 4.6m
Lcbm15 cb461 cb462 4.68n
Ccbm15 cb462 0 2.3111p
Rcbm16 cb462 cb463 4.6m
Lcbm16 cb463 cb464 4.68n
Ccbm16 cb464 0 2.3111p
Rcbm17 cb464 cb465 4.6m
Lcbm17 cb465 cb466 4.68n
Ccbm17 cb466 0 2.3111p
Rcbm18 cb466 cb467 4.6m
Lcbm18 cb467 cb468 4.68n
Ccbm18 cb468 0 2.3111p
Rcbm19 cb468 cb469 4.6m
Lcbm19 cb469 cb470 4.68n
Ccbm19 cb470 0 2.3111p
Rcbm20 cb470 cb471 4.6m
Lcbm20 cb471 cb472 4.68n
Ccbm20 cb472 0 2.3111p
Rcbm21 cb472 cb473 4.6m
Lcbm21 cb473 cb474 4.68n
Ccbm21 cb474 0 2.3111p
Rcbm22 cb474 cb475 4.6m
Lcbm22 cb475 cb476 4.68n
Ccbm22 cb476 0 2.3111p
Rcbm23 cb476 cb477 4.6m
Lcbm23 cb477 cb478 4.68n
Ccbm23 cb478 0 2.3111p
Rcbm24 cb478 cb479 4.6m
Lcbm24 cb479 cb480 4.68n
Ccbm24 cb480 0 2.3111p
Rcbm25 cb480 cb481 4.6m
Lcbm25 cb481 cb482 4.68n
Ccbm25 cb482 0 2.3111p
Rcbm26 cb482 cb483 4.6m
Lcbm26 cb483 cb484 4.68n
Ccbm26 cb484 0 2.3111p
Rcbm27 cb484 cb485 4.6m
Lcbm27 cb485 cb486 4.68n
Ccbm27 cb486 0 2.3111p
Rcbm28 cb486 cb487 4.6m
Lcbm28 cb487 cb488 4.68n
Ccbm28 cb488 0 2.3111p
Rcbm29 cb488 cb489 4.6m
Lcbm29 cb489 cb490 4.68n
Ccbm29 cb490 0 2.3111p
Rcbm30 cb490 cb491 4.6m
Lcbm30 cb491 cb492 4.68n
Ccbm30 cb492 0 2.3111p
Rcbm31 cb492 cb493 4.6m
Lcbm31 cb493 cb494 4.68n
Ccbm31 cb494 0 2.3111p
Rcbm32 cb494 cb495 4.6m
Lcbm32 cb495 cb496 4.68n
Ccbm32 cb496 0 2.3111p
Rcbm33 cb496 cb497 4.6m
Lcbm33 cb497 cb498 4.68n
Ccbm33 cb498 0 2.3111p
Rcbm34 cb498 cb499 4.6m
Lcbm34 cb499 cb500 4.68n
Ccbm34 cb500 0 2.3111p
Rcbm35 cb500 cb501 4.6m
Lcbm35 cb501 cb502 4.68n
Ccbm35 cb502 0 2.3111p
Rcbm36 cb502 cb503 4.6m
Lcbm36 cb503 cb504 4.68n
Ccbm36 cb504 0 2.3111p
Rcbm37 cb504 cb505 4.6m
Lcbm37 cb505 cb506 4.68n
Ccbm37 cb506 0 2.3111p
Rcbm38 cb506 cb507 4.6m
Lcbm38 cb507 cb508 4.68n
Ccbm38 cb508 0 2.3111p
Rcbm39 cb508 cb509 4.6m
Lcbm39 cb509 cb510 4.68n
Ccbm39 cb510 0 2.3111p
Rcbm40 cb510 cb511 4.6m
Lcbm40 cb511 cb512 4.68n
Ccbm40 cb512 0 2.3111p
Rcbm41 cb512 cb513 4.6m
Lcbm41 cb513 cb514 4.68n
Ccbm41 cb514 0 2.3111p
Rcbm42 cb514 cb515 4.6m
Lcbm42 cb515 cb516 4.68n
Ccbm42 cb516 0 2.3111p
Rcbm43 cb516 cb517 4.6m
Lcbm43 cb517 cb518 4.68n
Ccbm43 cb518 0 2.3111p
Rcbm44 cb518 cb519 4.6m
Lcbm44 cb519 cb520 4.68n
Ccbm44 cb520 0 2.3111p
Rcbm45 cb520 cb521 4.6m
Lcbm45 cb521 cb522 4.68n
Ccbm45 cb522 0 2.3111p
Rcbm46 cb522 cb523 4.6m
Lcbm46 cb523 cb524 4.68n
Ccbm46 cb524 0 2.3111p
Rcbm47 cb524 cb525 4.6m
Lcbm47 cb525 cb526 4.68n
Ccbm47 cb526 0 2.3111p
Rcbm48 cb526 cb527 4.6m
Lcbm48 cb527 cb528 4.68n
Ccbm48 cb528 0 2.3111p
Rcbm49 cb528 cb529 4.6m
Lcbm49 cb529 hm 4.68n
Ccbm49 hm 0 2.3111p
Chp hp 0 20.0p
Chm hm 0 20.0p
Rhp hp 0 15k
Rhm hm 0 15k
Vhp shp 0 PWL(0.0000n 3.3 331.3333n 3.3 335.3333n 0 414.6667n 0 418.6667n 3.3 498.0000n 3.3 502.0000n 0 581.3333n 0 585.3333n 3.3 664.6667n 3.3 668.6667n 0 748.0000n 0 752.0000n 3.3 831.3333n 3.3 835.3333n 0 998.0000n 0 1002.0000n 3.3 1081.3333n 3.3 1085.3333n 0 1331.3333n 0 1335.3333n 3.3 1498.0000n 3.3 1502.0000n 0 1581.3333n 0 1585.3333n 3.3 2164.6667n 3.3 2168.6667n 0 2248.0000n 0 2252.0000n 3.3 2331.3333n 3.3 2335.3333n 0 2914.6667n 0 2918.6667n 3.3 2998.0000n 3.3 3002.0000n 0 3081.3333n 0 3085.3333n 3.3 3248.0000n 3.3 3252.0000n 0 3414.6667n 0 3418.6667n 3.3 3664.6667n 3.3 3668.6667n 0 3998.0000n 0 4002.0000n 3.3 4081.3333n 3.3 4085.3333n 0 4164.6667n 0 4168.6667n 3.3 4581.3333n 3.3 4585.3333n 0 4664.6667n 0 4668.6667n 3.3 4748.0000n 3.3 4752.0000n 0 4914.6667n 0 4918.6667n 3.3 5081.3333n 3.3 5085.3333n 0 5164.6667n 0 5168.6667n 3.3)
Vhm shm 0 PWL(0.0000n 0 331.3333n 0 335.3333n 3.3 414.6667n 3.3 418.6667n 0 498.0000n 0 502.0000n 3.3 581.3333n 3.3 585.3333n 0 664.6667n 0 668.6667n 3.3 748.0000n 3.3 752.0000n 0 831.3333n 0 835.3333n 3.3 998.0000n 3.3 1002.0000n 0 1081.3333n 0 1085.3333n 3.3 1331.3333n 3.3 1335.3333n 0 1498.0000n 0 1502.0000n 3.3 1581.3333n 3.3 1585.3333n 0 2164.6667n 0 2168.6667n 3.3 2248.0000n 3.3 2252.0000n 0 2331.3333n 0 2335.3333n 3.3 2914.6667n 3.3 2918.6667n 0 2998.0000n 0 3002.0000n 3.3 3081.3333n 3.3 3085.3333n 0 3248.0000n 0 3252.0000n 3.3 3414.6667n 3.3 3418.6667n 0 3664.6667n 0 3668.6667n 3.3 3998.0000n 3.3 4002.0000n 0 4081.3333n 0 4085.3333n 3.3 4164.6667n 3.3 4168.6667n 0 4581.3333n 0 4585.3333n 3.3 4664.6667n 3.3 4668.6667n 0 4748.0000n 0 4752.0000n 3.3 4914.6667n 3.3 4918.6667n 0 5081.3333n 0 5085.3333n 3.3 5164.6667n 3.3 5168.6667n 0)
Rhdp shp hp 36
Rhdm shm hm 36
.options method=gear reltol=2e-3
.tran 0.1n 5333.3n 0 0.2n
.control
set wr_singlescale
set wr_vecnames
set numdgt=7
run

wrdata /out/usb_06_host_tx_4ns.txt v(pinp) v(pinm) v(conp) v(conm)
.endc
.end
