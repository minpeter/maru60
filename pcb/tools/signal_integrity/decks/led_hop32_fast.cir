* led_hop32_fast: SK6805 DOUT (assumed 20 ohm, 2 ns) -> 0.001 ohm in series -> routed hop -> DIN 5 pF
Vsrc src 0 PWL(0.0000n 0 100.0000n 0 102.0000n 4 400.0000n 4 402.0000n 0 1300.0000n 0 1302.0000n 4 2200.0000n 4 2202.0000n 0 2500.0000n 0 2502.0000n 4 2800.0000n 4 2802.0000n 0 3700.0000n 0 3702.0000n 4 4600.0000n 4 4602.0000n 0)
Rdrv src dout 20.0
Cdout dout 0 2p
Rt3 dout tm1 0.0045174
Lt3 tm1 t2 0.717928n
Ct3 t2 0 0.171024p
Rt5 t2 tm4 0.0045174
Lt5 tm4 rs_a 0.717928n
Ct5 rs_a 0 0.171024p
Rser rs_a rs_b 0.001
Cser rs_b 0 0.1p
Rt9 rs_b tm7 0.00446215
Lt9 tm7 t8 0.709147n
Ct9 t8 0 0.168932p
Rt11 t8 tm10 0.00446215
Lt11 tm10 p6 0.709147n
Ct11 p6 0 0.168932p
Lv13 p6 v12 1.358n
Cv13 v12 0 0.4885p
Rt17 v12 tm15 0.00635329
Lt17 tm15 t16 0.853723n
Ct17 t16 0 0.158297p
Rt20 t16 tm18 0.00635329
Lt20 tm18 t19 0.853723n
Ct20 t19 0 0.158297p
Rt23 t19 tm21 0.00635329
Lt23 tm21 t22 0.853723n
Ct23 t22 0 0.158297p
Rt26 t22 tm24 0.00635329
Lt26 tm24 t25 0.853723n
Ct26 t25 0 0.158297p
Rt29 t25 tm27 0.00635329
Lt29 tm27 t28 0.853723n
Ct29 t28 0 0.158297p
Rt32 t28 tm30 0.00635329
Lt32 tm30 t31 0.853723n
Ct32 t31 0 0.158297p
Rt35 t31 tm33 0.00635329
Lt35 tm33 t34 0.853723n
Ct35 t34 0 0.158297p
Rt38 t34 tm36 0.00635329
Lt38 tm36 t37 0.853723n
Ct38 t37 0 0.158297p
Rt41 t37 tm39 0.00635329
Lt41 tm39 t40 0.853723n
Ct41 t40 0 0.158297p
Rt44 t40 tm42 0.00635329
Lt44 tm42 t43 0.853723n
Ct44 t43 0 0.158297p
Rt47 t43 tm45 0.00635329
Lt47 tm45 t46 0.853723n
Ct47 t46 0 0.158297p
Rt50 t46 tm48 0.00635329
Lt50 tm48 t49 0.853723n
Ct50 t49 0 0.158297p
Rt53 t49 tm51 0.00635329
Lt53 tm51 t52 0.853723n
Ct53 t52 0 0.158297p
Rt55 t52 tm54 0.00635329
Lt55 tm54 p14 0.853723n
Ct55 p14 0 0.158297p
Lv57 p14 v56 1.358n
Cv57 v56 0 0.4885p
Rt61 v56 tm59 0.00548266
Lt61 tm59 t60 0.736731n
Ct61 t60 0 0.136605p
Rt64 t60 tm62 0.00548266
Lt64 tm62 t63 0.736731n
Ct64 t63 0 0.136605p
Rt67 t63 tm65 0.00548266
Lt67 tm65 t66 0.736731n
Ct67 t66 0 0.136605p
Rt70 t66 tm68 0.00548266
Lt70 tm68 t69 0.736731n
Ct70 t69 0 0.136605p
Rt73 t69 tm71 0.00548266
Lt73 tm71 t72 0.736731n
Ct73 t72 0 0.136605p
Rt75 t72 tm74 0.00548266
Lt75 tm74 p58 0.736731n
Ct75 p58 0 0.136605p
Lv77 p58 v76 1.358n
Cv77 v76 0 0.4885p
Rt81 v76 tm79 0.0064915
Lt81 tm79 t80 0.872294n
Ct81 t80 0 0.161741p
Rt84 t80 tm82 0.0064915
Lt84 tm82 t83 0.872294n
Ct84 t83 0 0.161741p
Rt87 t83 tm85 0.0064915
Lt87 tm85 t86 0.872294n
Ct87 t86 0 0.161741p
Rt90 t86 tm88 0.0064915
Lt90 tm88 t89 0.872294n
Ct90 t89 0 0.161741p
Rt93 t89 tm91 0.0064915
Lt93 tm91 t92 0.872294n
Ct93 t92 0 0.161741p
Rt96 t92 tm94 0.0064915
Lt96 tm94 t95 0.872294n
Ct96 t95 0 0.161741p
Rt99 t95 tm97 0.0064915
Lt99 tm97 t98 0.872294n
Ct99 t98 0 0.161741p
Rt102 t98 tm100 0.0064915
Lt102 tm100 t101 0.872294n
Ct102 t101 0 0.161741p
Rt105 t101 tm103 0.0064915
Lt105 tm103 t104 0.872294n
Ct105 t104 0 0.161741p
Rt108 t104 tm106 0.0064915
Lt108 tm106 t107 0.872294n
Ct108 t107 0 0.161741p
Rt111 t107 tm109 0.0064915
Lt111 tm109 t110 0.872294n
Ct111 t110 0 0.161741p
Rt114 t110 tm112 0.0064915
Lt114 tm112 t113 0.872294n
Ct114 t113 0 0.161741p
Rt117 t113 tm115 0.0064915
Lt117 tm115 t116 0.872294n
Ct117 t116 0 0.161741p
Rt120 t116 tm118 0.0064915
Lt120 tm118 t119 0.872294n
Ct120 t119 0 0.161741p
Rt123 t119 tm121 0.0064915
Lt123 tm121 t122 0.872294n
Ct123 t122 0 0.161741p
Rt126 t122 tm124 0.0064915
Lt126 tm124 t125 0.872294n
Ct126 t125 0 0.161741p
Rt129 t125 tm127 0.0064915
Lt129 tm127 t128 0.872294n
Ct129 t128 0 0.161741p
Rt132 t128 tm130 0.0064915
Lt132 tm130 t131 0.872294n
Ct132 t131 0 0.161741p
Rt135 t131 tm133 0.0064915
Lt135 tm133 t134 0.872294n
Ct135 t134 0 0.161741p
Rt138 t134 tm136 0.0064915
Lt138 tm136 t137 0.872294n
Ct138 t137 0 0.161741p
Rt141 t137 tm139 0.0064915
Lt141 tm139 t140 0.872294n
Ct141 t140 0 0.161741p
Rt144 t140 tm142 0.0064915
Lt144 tm142 t143 0.872294n
Ct144 t143 0 0.161741p
Rt147 t143 tm145 0.0064915
Lt147 tm145 t146 0.872294n
Ct147 t146 0 0.161741p
Rt150 t146 tm148 0.0064915
Lt150 tm148 t149 0.872294n
Ct150 t149 0 0.161741p
Rt153 t149 tm151 0.0064915
Lt153 tm151 t152 0.872294n
Ct153 t152 0 0.161741p
Rt156 t152 tm154 0.0064915
Lt156 tm154 t155 0.872294n
Ct156 t155 0 0.161741p
Rt159 t155 tm157 0.0064915
Lt159 tm157 t158 0.872294n
Ct159 t158 0 0.161741p
Rt162 t158 tm160 0.0064915
Lt162 tm160 t161 0.872294n
Ct162 t161 0 0.161741p
Rt165 t161 tm163 0.0064915
Lt165 tm163 t164 0.872294n
Ct165 t164 0 0.161741p
Rt168 t164 tm166 0.0064915
Lt168 tm166 t167 0.872294n
Ct168 t167 0 0.161741p
Rt171 t167 tm169 0.0064915
Lt171 tm169 t170 0.872294n
Ct171 t170 0 0.161741p
Rt174 t170 tm172 0.0064915
Lt174 tm172 t173 0.872294n
Ct174 t173 0 0.161741p
Rt177 t173 tm175 0.0064915
Lt177 tm175 t176 0.872294n
Ct177 t176 0 0.161741p
Rt180 t176 tm178 0.0064915
Lt180 tm178 t179 0.872294n
Ct180 t179 0 0.161741p
Rt183 t179 tm181 0.0064915
Lt183 tm181 t182 0.872294n
Ct183 t182 0 0.161741p
Rt186 t182 tm184 0.0064915
Lt186 tm184 t185 0.872294n
Ct186 t185 0 0.161741p
Rt189 t185 tm187 0.0064915
Lt189 tm187 t188 0.872294n
Ct189 t188 0 0.161741p
Rt192 t188 tm190 0.0064915
Lt192 tm190 t191 0.872294n
Ct192 t191 0 0.161741p
Rt195 t191 tm193 0.0064915
Lt195 tm193 t194 0.872294n
Ct195 t194 0 0.161741p
Rt198 t194 tm196 0.0064915
Lt198 tm196 t197 0.872294n
Ct198 t197 0 0.161741p
Rt201 t197 tm199 0.0064915
Lt201 tm199 t200 0.872294n
Ct201 t200 0 0.161741p
Rt204 t200 tm202 0.0064915
Lt204 tm202 t203 0.872294n
Ct204 t203 0 0.161741p
Rt207 t203 tm205 0.0064915
Lt207 tm205 t206 0.872294n
Ct207 t206 0 0.161741p
Rt210 t206 tm208 0.0064915
Lt210 tm208 t209 0.872294n
Ct210 t209 0 0.161741p
Rt213 t209 tm211 0.0064915
Lt213 tm211 t212 0.872294n
Ct213 t212 0 0.161741p
Rt216 t212 tm214 0.0064915
Lt216 tm214 t215 0.872294n
Ct216 t215 0 0.161741p
Rt219 t215 tm217 0.0064915
Lt219 tm217 t218 0.872294n
Ct219 t218 0 0.161741p
Rt222 t218 tm220 0.0064915
Lt222 tm220 t221 0.872294n
Ct222 t221 0 0.161741p
Rt225 t221 tm223 0.0064915
Lt225 tm223 t224 0.872294n
Ct225 t224 0 0.161741p
Rt228 t224 tm226 0.0064915
Lt228 tm226 t227 0.872294n
Ct228 t227 0 0.161741p
Rt231 t227 tm229 0.0064915
Lt231 tm229 t230 0.872294n
Ct231 t230 0 0.161741p
Rt234 t230 tm232 0.0064915
Lt234 tm232 t233 0.872294n
Ct234 t233 0 0.161741p
Rt237 t233 tm235 0.0064915
Lt237 tm235 t236 0.872294n
Ct237 t236 0 0.161741p
Rt240 t236 tm238 0.0064915
Lt240 tm238 t239 0.872294n
Ct240 t239 0 0.161741p
Rt243 t239 tm241 0.0064915
Lt243 tm241 t242 0.872294n
Ct243 t242 0 0.161741p
Rt246 t242 tm244 0.0064915
Lt246 tm244 t245 0.872294n
Ct246 t245 0 0.161741p
Rt249 t245 tm247 0.0064915
Lt249 tm247 t248 0.872294n
Ct249 t248 0 0.161741p
Rt252 t248 tm250 0.0064915
Lt252 tm250 t251 0.872294n
Ct252 t251 0 0.161741p
Rt255 t251 tm253 0.0064915
Lt255 tm253 t254 0.872294n
Ct255 t254 0 0.161741p
Rt258 t254 tm256 0.0064915
Lt258 tm256 t257 0.872294n
Ct258 t257 0 0.161741p
Rt261 t257 tm259 0.0064915
Lt261 tm259 t260 0.872294n
Ct261 t260 0 0.161741p
Rt264 t260 tm262 0.0064915
Lt264 tm262 t263 0.872294n
Ct264 t263 0 0.161741p
Rt267 t263 tm265 0.0064915
Lt267 tm265 t266 0.872294n
Ct267 t266 0 0.161741p
Rt270 t266 tm268 0.0064915
Lt270 tm268 t269 0.872294n
Ct270 t269 0 0.161741p
Rt273 t269 tm271 0.0064915
Lt273 tm271 t272 0.872294n
Ct273 t272 0 0.161741p
Rt276 t272 tm274 0.0064915
Lt276 tm274 t275 0.872294n
Ct276 t275 0 0.161741p
Rt279 t275 tm277 0.0064915
Lt279 tm277 t278 0.872294n
Ct279 t278 0 0.161741p
Rt282 t278 tm280 0.0064915
Lt282 tm280 t281 0.872294n
Ct282 t281 0 0.161741p
Rt285 t281 tm283 0.0064915
Lt285 tm283 t284 0.872294n
Ct285 t284 0 0.161741p
Rt288 t284 tm286 0.0064915
Lt288 tm286 t287 0.872294n
Ct288 t287 0 0.161741p
Rt291 t287 tm289 0.0064915
Lt291 tm289 t290 0.872294n
Ct291 t290 0 0.161741p
Rt294 t290 tm292 0.0064915
Lt294 tm292 t293 0.872294n
Ct294 t293 0 0.161741p
Rt296 t293 tm295 0.0064915
Lt296 tm295 p78 0.872294n
Ct296 p78 0 0.161741p
Lv298 p78 v297 1.358n
Cv298 v297 0 0.4885p
Rt302 v297 tm300 0.0046778
Lt302 tm300 t301 0.628579n
Ct302 t301 0 0.116551p
Rt304 t301 tm303 0.0046778
Lt304 tm303 p299 0.628579n
Ct304 p299 0 0.116551p
Lv306 p299 v305 1.358n
Cv306 v305 0 0.4885p
Rt310 v305 tm308 0.00409042
Lt310 tm308 t309 0.549649n
Ct310 t309 0 0.101916p
Rt312 t309 tm311 0.00409042
Lt312 tm311 p307 0.549649n
Ct312 p307 0 0.101916p
Lv314 p307 v313 1.358n
Cv314 v313 0 0.4885p
Rt318 v313 tm316 0.00567519
Lt318 tm316 t317 0.762603n
Ct318 t317 0 0.141402p
Rt321 t317 tm319 0.00567519
Lt321 tm319 t320 0.762603n
Ct321 t320 0 0.141402p
Rt324 t320 tm322 0.00567519
Lt324 tm322 t323 0.762603n
Ct324 t323 0 0.141402p
Rt327 t323 tm325 0.00567519
Lt327 tm325 t326 0.762603n
Ct327 t326 0 0.141402p
Rt329 t326 tm328 0.00567519
Lt329 tm328 p315 0.762603n
Ct329 p315 0 0.141402p
Lv331 p315 v330 1.358n
Cv331 v330 0 0.4885p
Rt335 v330 tm333 0.00627863
Lt335 tm333 t334 0.84369n
Ct335 t334 0 0.156437p
Rt338 t334 tm336 0.00627863
Lt338 tm336 t337 0.84369n
Ct338 t337 0 0.156437p
Rt341 t337 tm339 0.00627863
Lt341 tm339 t340 0.84369n
Ct341 t340 0 0.156437p
Rt344 t340 tm342 0.00627863
Lt344 tm342 t343 0.84369n
Ct344 t343 0 0.156437p
Rt347 t343 tm345 0.00627863
Lt347 tm345 t346 0.84369n
Ct347 t346 0 0.156437p
Rt350 t346 tm348 0.00627863
Lt350 tm348 t349 0.84369n
Ct350 t349 0 0.156437p
Rt353 t349 tm351 0.00627863
Lt353 tm351 t352 0.84369n
Ct353 t352 0 0.156437p
Rt356 t352 tm354 0.00627863
Lt356 tm354 t355 0.84369n
Ct356 t355 0 0.156437p
Rt359 t355 tm357 0.00627863
Lt359 tm357 t358 0.84369n
Ct359 t358 0 0.156437p
Rt362 t358 tm360 0.00627863
Lt362 tm360 t361 0.84369n
Ct362 t361 0 0.156437p
Rt365 t361 tm363 0.00627863
Lt365 tm363 t364 0.84369n
Ct365 t364 0 0.156437p
Rt368 t364 tm366 0.00627863
Lt368 tm366 t367 0.84369n
Ct368 t367 0 0.156437p
Rt371 t367 tm369 0.00627863
Lt371 tm369 t370 0.84369n
Ct371 t370 0 0.156437p
Rt374 t370 tm372 0.00627863
Lt374 tm372 t373 0.84369n
Ct374 t373 0 0.156437p
Rt377 t373 tm375 0.00627863
Lt377 tm375 t376 0.84369n
Ct377 t376 0 0.156437p
Rt380 t376 tm378 0.00627863
Lt380 tm378 t379 0.84369n
Ct380 t379 0 0.156437p
Rt383 t379 tm381 0.00627863
Lt383 tm381 t382 0.84369n
Ct383 t382 0 0.156437p
Rt386 t382 tm384 0.00627863
Lt386 tm384 t385 0.84369n
Ct386 t385 0 0.156437p
Rt389 t385 tm387 0.00627863
Lt389 tm387 t388 0.84369n
Ct389 t388 0 0.156437p
Rt392 t388 tm390 0.00627863
Lt392 tm390 t391 0.84369n
Ct392 t391 0 0.156437p
Rt395 t391 tm393 0.00627863
Lt395 tm393 t394 0.84369n
Ct395 t394 0 0.156437p
Rt398 t394 tm396 0.00627863
Lt398 tm396 t397 0.84369n
Ct398 t397 0 0.156437p
Rt400 t397 tm399 0.00627863
Lt400 tm399 p332 0.84369n
Ct400 p332 0 0.156437p
Lv402 p332 v401 1.358n
Cv402 v401 0 0.4885p
Rt405 v401 tm403 0.0062357
Lt405 tm403 t404 0.837921n
Ct405 t404 0 0.155367p
Rt408 t404 tm406 0.0062357
Lt408 tm406 t407 0.837921n
Ct408 t407 0 0.155367p
Rt411 t407 tm409 0.0062357
Lt411 tm409 t410 0.837921n
Ct411 t410 0 0.155367p
Rt414 t410 tm412 0.0062357
Lt414 tm412 t413 0.837921n
Ct414 t413 0 0.155367p
Rt417 t413 tm415 0.0062357
Lt417 tm415 t416 0.837921n
Ct417 t416 0 0.155367p
Rt420 t416 tm418 0.0062357
Lt420 tm418 t419 0.837921n
Ct420 t419 0 0.155367p
Rt423 t419 tm421 0.0062357
Lt423 tm421 t422 0.837921n
Ct423 t422 0 0.155367p
Rt426 t422 tm424 0.0062357
Lt426 tm424 t425 0.837921n
Ct426 t425 0 0.155367p
Rt429 t425 tm427 0.0062357
Lt429 tm427 t428 0.837921n
Ct429 t428 0 0.155367p
Rt432 t428 tm430 0.0062357
Lt432 tm430 t431 0.837921n
Ct432 t431 0 0.155367p
Rt435 t431 tm433 0.0062357
Lt435 tm433 t434 0.837921n
Ct435 t434 0 0.155367p
Rt438 t434 tm436 0.0062357
Lt438 tm436 t437 0.837921n
Ct438 t437 0 0.155367p
Rt441 t437 tm439 0.0062357
Lt441 tm439 t440 0.837921n
Ct441 t440 0 0.155367p
Rt444 t440 tm442 0.0062357
Lt444 tm442 t443 0.837921n
Ct444 t443 0 0.155367p
Rt447 t443 tm445 0.0062357
Lt447 tm445 t446 0.837921n
Ct447 t446 0 0.155367p
Rt449 t446 tm448 0.0062357
Lt449 tm448 din 0.837921n
Ct449 din 0 0.155367p
Cin din 0 5p
.tran 0.1n 5000n 0 0.2n
.control
set wr_singlescale
set wr_vecnames
set numdgt=7
run

wrdata /out/led_hop32_fast.txt v(dout) v(din)
.endc
.end
