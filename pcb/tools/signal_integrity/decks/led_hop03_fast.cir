* led_hop03_fast: SK6805 DOUT (assumed 20 ohm, 2 ns) -> routed hop -> DIN 5 pF
Vsrc src 0 PWL(0.0000n 0 100.0000n 0 102.0000n 4 400.0000n 4 402.0000n 0 1300.0000n 0 1302.0000n 4 2200.0000n 4 2202.0000n 0 2500.0000n 0 2502.0000n 4 2800.0000n 4 2802.0000n 0 3700.0000n 0 3702.0000n 4 4600.0000n 4 4602.0000n 0)
Rdrv src dout 20.0
Cdout dout 0 2p
Rt3 dout tm2 0.00245714
Lt3 tm2 p1 0.330178n
Ct3 p1 0 0.0612216p
Lv5 p1 v4 1.358n
Cv5 v4 0 0.4885p
Rt9 v4 tm7 0.0062368
Lt9 tm7 t8 0.838069n
Ct9 t8 0 0.155395p
Rt12 t8 tm10 0.0062368
Lt12 tm10 t11 0.838069n
Ct12 t11 0 0.155395p
Rt15 t11 tm13 0.0062368
Lt15 tm13 t14 0.838069n
Ct15 t14 0 0.155395p
Rt18 t14 tm16 0.0062368
Lt18 tm16 t17 0.838069n
Ct18 t17 0 0.155395p
Rt20 t17 tm19 0.0062368
Lt20 tm19 p6 0.838069n
Ct20 p6 0 0.155395p
Lv22 p6 v21 1.358n
Cv22 v21 0 0.4885p
Rt26 v21 tm24 0.00564667
Lt26 tm24 t25 0.75877n
Ct26 t25 0 0.140691p
Rt29 t25 tm27 0.00564667
Lt29 tm27 t28 0.75877n
Ct29 t28 0 0.140691p
Rt32 t28 tm30 0.00564667
Lt32 tm30 t31 0.75877n
Ct32 t31 0 0.140691p
Rt35 t31 tm33 0.00564667
Lt35 tm33 t34 0.75877n
Ct35 t34 0 0.140691p
Rt38 t34 tm36 0.00564667
Lt38 tm36 t37 0.75877n
Ct38 t37 0 0.140691p
Rt41 t37 tm39 0.00564667
Lt41 tm39 t40 0.75877n
Ct41 t40 0 0.140691p
Rt43 t40 tm42 0.00564667
Lt43 tm42 p23 0.75877n
Ct43 p23 0 0.140691p
Lv45 p23 v44 1.358n
Cv45 v44 0 0.4885p
Rt49 v44 tm47 0.00591172
Lt49 tm47 t48 0.794387n
Ct49 t48 0 0.147295p
Rt52 t48 tm50 0.00591172
Lt52 tm50 t51 0.794387n
Ct52 t51 0 0.147295p
Rt54 t51 tm53 0.00591172
Lt54 tm53 p46 0.794387n
Ct54 p46 0 0.147295p
Lv56 p46 v55 1.358n
Cv56 v55 0 0.4885p
Rt60 v55 tm58 0.00603927
Lt60 tm58 t59 0.811526n
Ct60 t59 0 0.150473p
Rt63 t59 tm61 0.00603927
Lt63 tm61 t62 0.811526n
Ct63 t62 0 0.150473p
Rt66 t62 tm64 0.00603927
Lt66 tm64 t65 0.811526n
Ct66 t65 0 0.150473p
Rt69 t65 tm67 0.00603927
Lt69 tm67 t68 0.811526n
Ct69 t68 0 0.150473p
Rt72 t68 tm70 0.00603927
Lt72 tm70 t71 0.811526n
Ct72 t71 0 0.150473p
Rt75 t71 tm73 0.00603927
Lt75 tm73 t74 0.811526n
Ct75 t74 0 0.150473p
Rt78 t74 tm76 0.00603927
Lt78 tm76 t77 0.811526n
Ct78 t77 0 0.150473p
Rt80 t77 tm79 0.00603927
Lt80 tm79 p57 0.811526n
Ct80 p57 0 0.150473p
Lv82 p57 v81 1.358n
Cv82 v81 0 0.4885p
Rt86 v81 tm84 0.00651009
Lt86 tm84 t85 0.874792n
Ct86 t85 0 0.162204p
Rt89 t85 tm87 0.00651009
Lt89 tm87 t88 0.874792n
Ct89 t88 0 0.162204p
Rt91 t88 tm90 0.00651009
Lt91 tm90 p83 0.874792n
Ct91 p83 0 0.162204p
Lv93 p83 v92 1.358n
Cv93 v92 0 0.4885p
Rt97 v92 tm95 0.00561609
Lt97 tm95 t96 0.754661n
Ct97 t96 0 0.139929p
Rt100 t96 tm98 0.00561609
Lt100 tm98 t99 0.754661n
Ct100 t99 0 0.139929p
Rt103 t99 tm101 0.00561609
Lt103 tm101 t102 0.754661n
Ct103 t102 0 0.139929p
Rt106 t102 tm104 0.00561609
Lt106 tm104 t105 0.754661n
Ct106 t105 0 0.139929p
Rt108 t105 tm107 0.00561609
Lt108 tm107 p94 0.754661n
Ct108 p94 0 0.139929p
Lv110 p94 v109 1.358n
Cv110 v109 0 0.4885p
Rt114 v109 tm112 0.00505631
Lt114 tm112 t113 0.679441n
Ct114 t113 0 0.125982p
Rt117 t113 tm115 0.00505631
Lt117 tm115 t116 0.679441n
Ct117 t116 0 0.125982p
Rt120 t116 tm118 0.00505631
Lt120 tm118 t119 0.679441n
Ct120 t119 0 0.125982p
Rt122 t119 tm121 0.00505631
Lt122 tm121 p111 0.679441n
Ct122 p111 0 0.125982p
Lv124 p111 v123 1.358n
Cv124 v123 0 0.4885p
Rt126 v123 tm125 0.00351949
Lt126 tm125 din 0.472931n
Ct126 din 0 0.0876909p
Cin din 0 5p
.tran 0.1n 5000n 0 0.2n
.control
set wr_singlescale
set wr_vecnames
set numdgt=7
run

wrdata /out/led_hop03_fast.txt v(dout) v(din)
.endc
.end
