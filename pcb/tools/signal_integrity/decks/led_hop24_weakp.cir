* led_hop24_weakp: SK6805 DOUT (assumed 1000 ohm, 30 ns) -> routed hop -> DIN 15 pF
Vsrc src 0 PWL(0.0000n 0 100.0000n 0 130.0000n 4 400.0000n 4 430.0000n 0 1300.0000n 0 1330.0000n 4 2200.0000n 4 2230.0000n 0 2500.0000n 0 2530.0000n 4 2800.0000n 4 2830.0000n 0 3700.0000n 0 3730.0000n 4 4600.0000n 4 4630.0000n 0)
Rdrv src dout 1000.0
Cdout dout 0 2p
Rt4 dout tm2 0.00401129
Lt4 tm2 t3 0.637493n
Ct4 t3 0 0.151863p
Rt7 t3 tm5 0.00401129
Lt7 tm5 t6 0.637493n
Ct7 t6 0 0.151863p
Rt10 t6 tm8 0.00401129
Lt10 tm8 t9 0.637493n
Ct10 t9 0 0.151863p
Rt12 t9 tm11 0.00401129
Lt12 tm11 p1 0.637493n
Ct12 p1 0 0.151863p
Rs16 p1 sm14 0.00441352
Ls16 sm14 s15 0.701418n
Cs16 s15 0 0.167091p
Rs19 s15 sm17 0.00441352
Ls19 sm17 s18 0.701418n
Cs19 s18 0 0.167091p
Rs22 s18 sm20 0.00441352
Ls22 sm20 s21 0.701418n
Cs22 s21 0 0.167091p
Rs25 s21 sm23 0.00441352
Ls25 sm23 s24 0.701418n
Cs25 s24 0 0.167091p
Rs27 s24 sm26 0.00441352
Ls27 sm26 stubend13 0.701418n
Cs27 stubend13 0 0.167091p
Cs28 stubend13 0 0.15p
Rt32 p1 tm30 0.00435824
Lt32 tm30 t31 0.692634n
Ct32 t31 0 0.164998p
Rt35 t31 tm33 0.00435824
Lt35 tm33 t34 0.692634n
Ct35 t34 0 0.164998p
Rt38 t34 tm36 0.00435824
Lt38 tm36 t37 0.692634n
Ct38 t37 0 0.164998p
Rt40 t37 tm39 0.00435824
Lt40 tm39 p29 0.692634n
Ct40 p29 0 0.164998p
Rt43 p29 tm41 0.00567809
Lt43 tm41 t42 0.762992n
Ct43 t42 0 0.141474p
Rt46 t42 tm44 0.00567809
Lt46 tm44 t45 0.762992n
Ct46 t45 0 0.141474p
Rt49 t45 tm47 0.00567809
Lt49 tm47 t48 0.762992n
Ct49 t48 0 0.141474p
Rt52 t48 tm50 0.00567809
Lt52 tm50 t51 0.762992n
Ct52 t51 0 0.141474p
Rt54 t51 tm53 0.00567809
Lt54 tm53 din 0.762992n
Ct54 din 0 0.141474p
Cin din 0 15p
.tran 0.1n 5000n 0 0.2n
.control
set wr_singlescale
set wr_vecnames
set numdgt=7
run

wrdata /out/led_hop24_weakp.txt v(dout) v(din)
.endc
.end
