* led_hop00_nom: SK6805 DOUT (assumed 100 ohm, 10 ns) -> routed hop -> DIN 5 pF
Vsrc src 0 PWL(0.0000n 0 100.0000n 0 110.0000n 4 400.0000n 4 410.0000n 0 1300.0000n 0 1310.0000n 4 2200.0000n 4 2210.0000n 0 2500.0000n 0 2510.0000n 4 2800.0000n 4 2810.0000n 0 3700.0000n 0 3710.0000n 4 4600.0000n 4 4610.0000n 0)
Rdrv src dout 100.0
Cdout dout 0 2p
Rt4 dout tm2 0.00615115
Lt4 tm2 t3 0.826559n
Ct4 t3 0 0.153261p
Rt7 t3 tm5 0.00615115
Lt7 tm5 t6 0.826559n
Ct7 t6 0 0.153261p
Rt9 t6 tm8 0.00615115
Lt9 tm8 p1 0.826559n
Ct9 p1 0 0.153261p
Lv11 p1 v10 1.358n
Cv11 v10 0 0.4885p
Rt15 v10 tm13 0.00635329
Lt15 tm13 t14 0.853723n
Ct15 t14 0 0.158297p
Rt18 t14 tm16 0.00635329
Lt18 tm16 t17 0.853723n
Ct18 t17 0 0.158297p
Rt21 t17 tm19 0.00635329
Lt21 tm19 t20 0.853723n
Ct21 t20 0 0.158297p
Rt24 t20 tm22 0.00635329
Lt24 tm22 t23 0.853723n
Ct24 t23 0 0.158297p
Rt27 t23 tm25 0.00635329
Lt27 tm25 t26 0.853723n
Ct27 t26 0 0.158297p
Rt30 t26 tm28 0.00635329
Lt30 tm28 t29 0.853723n
Ct30 t29 0 0.158297p
Rt33 t29 tm31 0.00635329
Lt33 tm31 t32 0.853723n
Ct33 t32 0 0.158297p
Rt36 t32 tm34 0.00635329
Lt36 tm34 t35 0.853723n
Ct36 t35 0 0.158297p
Rt39 t35 tm37 0.00635329
Lt39 tm37 t38 0.853723n
Ct39 t38 0 0.158297p
Rt42 t38 tm40 0.00635329
Lt42 tm40 t41 0.853723n
Ct42 t41 0 0.158297p
Rt45 t41 tm43 0.00635329
Lt45 tm43 t44 0.853723n
Ct45 t44 0 0.158297p
Rt48 t44 tm46 0.00635329
Lt48 tm46 t47 0.853723n
Ct48 t47 0 0.158297p
Rt51 t47 tm49 0.00635329
Lt51 tm49 t50 0.853723n
Ct51 t50 0 0.158297p
Rt53 t50 tm52 0.00635329
Lt53 tm52 p12 0.853723n
Ct53 p12 0 0.158297p
Lv55 p12 v54 1.358n
Cv55 v54 0 0.4885p
Rt59 v54 tm57 0.00548266
Lt59 tm57 t58 0.736731n
Ct59 t58 0 0.136605p
Rt62 t58 tm60 0.00548266
Lt62 tm60 t61 0.736731n
Ct62 t61 0 0.136605p
Rt65 t61 tm63 0.00548266
Lt65 tm63 t64 0.736731n
Ct65 t64 0 0.136605p
Rt68 t64 tm66 0.00548266
Lt68 tm66 t67 0.736731n
Ct68 t67 0 0.136605p
Rt71 t67 tm69 0.00548266
Lt71 tm69 t70 0.736731n
Ct71 t70 0 0.136605p
Rt73 t70 tm72 0.00548266
Lt73 tm72 p56 0.736731n
Ct73 p56 0 0.136605p
Lv75 p56 v74 1.358n
Cv75 v74 0 0.4885p
Rt79 v74 tm77 0.0064915
Lt79 tm77 t78 0.872294n
Ct79 t78 0 0.161741p
Rt82 t78 tm80 0.0064915
Lt82 tm80 t81 0.872294n
Ct82 t81 0 0.161741p
Rt85 t81 tm83 0.0064915
Lt85 tm83 t84 0.872294n
Ct85 t84 0 0.161741p
Rt88 t84 tm86 0.0064915
Lt88 tm86 t87 0.872294n
Ct88 t87 0 0.161741p
Rt91 t87 tm89 0.0064915
Lt91 tm89 t90 0.872294n
Ct91 t90 0 0.161741p
Rt94 t90 tm92 0.0064915
Lt94 tm92 t93 0.872294n
Ct94 t93 0 0.161741p
Rt97 t93 tm95 0.0064915
Lt97 tm95 t96 0.872294n
Ct97 t96 0 0.161741p
Rt100 t96 tm98 0.0064915
Lt100 tm98 t99 0.872294n
Ct100 t99 0 0.161741p
Rt103 t99 tm101 0.0064915
Lt103 tm101 t102 0.872294n
Ct103 t102 0 0.161741p
Rt106 t102 tm104 0.0064915
Lt106 tm104 t105 0.872294n
Ct106 t105 0 0.161741p
Rt109 t105 tm107 0.0064915
Lt109 tm107 t108 0.872294n
Ct109 t108 0 0.161741p
Rt112 t108 tm110 0.0064915
Lt112 tm110 t111 0.872294n
Ct112 t111 0 0.161741p
Rt115 t111 tm113 0.0064915
Lt115 tm113 t114 0.872294n
Ct115 t114 0 0.161741p
Rt118 t114 tm116 0.0064915
Lt118 tm116 t117 0.872294n
Ct118 t117 0 0.161741p
Rt121 t117 tm119 0.0064915
Lt121 tm119 t120 0.872294n
Ct121 t120 0 0.161741p
Rt124 t120 tm122 0.0064915
Lt124 tm122 t123 0.872294n
Ct124 t123 0 0.161741p
Rt127 t123 tm125 0.0064915
Lt127 tm125 t126 0.872294n
Ct127 t126 0 0.161741p
Rt130 t126 tm128 0.0064915
Lt130 tm128 t129 0.872294n
Ct130 t129 0 0.161741p
Rt133 t129 tm131 0.0064915
Lt133 tm131 t132 0.872294n
Ct133 t132 0 0.161741p
Rt136 t132 tm134 0.0064915
Lt136 tm134 t135 0.872294n
Ct136 t135 0 0.161741p
Rt139 t135 tm137 0.0064915
Lt139 tm137 t138 0.872294n
Ct139 t138 0 0.161741p
Rt142 t138 tm140 0.0064915
Lt142 tm140 t141 0.872294n
Ct142 t141 0 0.161741p
Rt145 t141 tm143 0.0064915
Lt145 tm143 t144 0.872294n
Ct145 t144 0 0.161741p
Rt148 t144 tm146 0.0064915
Lt148 tm146 t147 0.872294n
Ct148 t147 0 0.161741p
Rt151 t147 tm149 0.0064915
Lt151 tm149 t150 0.872294n
Ct151 t150 0 0.161741p
Rt154 t150 tm152 0.0064915
Lt154 tm152 t153 0.872294n
Ct154 t153 0 0.161741p
Rt157 t153 tm155 0.0064915
Lt157 tm155 t156 0.872294n
Ct157 t156 0 0.161741p
Rt160 t156 tm158 0.0064915
Lt160 tm158 t159 0.872294n
Ct160 t159 0 0.161741p
Rt163 t159 tm161 0.0064915
Lt163 tm161 t162 0.872294n
Ct163 t162 0 0.161741p
Rt166 t162 tm164 0.0064915
Lt166 tm164 t165 0.872294n
Ct166 t165 0 0.161741p
Rt169 t165 tm167 0.0064915
Lt169 tm167 t168 0.872294n
Ct169 t168 0 0.161741p
Rt172 t168 tm170 0.0064915
Lt172 tm170 t171 0.872294n
Ct172 t171 0 0.161741p
Rt175 t171 tm173 0.0064915
Lt175 tm173 t174 0.872294n
Ct175 t174 0 0.161741p
Rt178 t174 tm176 0.0064915
Lt178 tm176 t177 0.872294n
Ct178 t177 0 0.161741p
Rt181 t177 tm179 0.0064915
Lt181 tm179 t180 0.872294n
Ct181 t180 0 0.161741p
Rt184 t180 tm182 0.0064915
Lt184 tm182 t183 0.872294n
Ct184 t183 0 0.161741p
Rt187 t183 tm185 0.0064915
Lt187 tm185 t186 0.872294n
Ct187 t186 0 0.161741p
Rt190 t186 tm188 0.0064915
Lt190 tm188 t189 0.872294n
Ct190 t189 0 0.161741p
Rt193 t189 tm191 0.0064915
Lt193 tm191 t192 0.872294n
Ct193 t192 0 0.161741p
Rt196 t192 tm194 0.0064915
Lt196 tm194 t195 0.872294n
Ct196 t195 0 0.161741p
Rt199 t195 tm197 0.0064915
Lt199 tm197 t198 0.872294n
Ct199 t198 0 0.161741p
Rt202 t198 tm200 0.0064915
Lt202 tm200 t201 0.872294n
Ct202 t201 0 0.161741p
Rt205 t201 tm203 0.0064915
Lt205 tm203 t204 0.872294n
Ct205 t204 0 0.161741p
Rt208 t204 tm206 0.0064915
Lt208 tm206 t207 0.872294n
Ct208 t207 0 0.161741p
Rt211 t207 tm209 0.0064915
Lt211 tm209 t210 0.872294n
Ct211 t210 0 0.161741p
Rt214 t210 tm212 0.0064915
Lt214 tm212 t213 0.872294n
Ct214 t213 0 0.161741p
Rt217 t213 tm215 0.0064915
Lt217 tm215 t216 0.872294n
Ct217 t216 0 0.161741p
Rt220 t216 tm218 0.0064915
Lt220 tm218 t219 0.872294n
Ct220 t219 0 0.161741p
Rt223 t219 tm221 0.0064915
Lt223 tm221 t222 0.872294n
Ct223 t222 0 0.161741p
Rt226 t222 tm224 0.0064915
Lt226 tm224 t225 0.872294n
Ct226 t225 0 0.161741p
Rt229 t225 tm227 0.0064915
Lt229 tm227 t228 0.872294n
Ct229 t228 0 0.161741p
Rt232 t228 tm230 0.0064915
Lt232 tm230 t231 0.872294n
Ct232 t231 0 0.161741p
Rt235 t231 tm233 0.0064915
Lt235 tm233 t234 0.872294n
Ct235 t234 0 0.161741p
Rt238 t234 tm236 0.0064915
Lt238 tm236 t237 0.872294n
Ct238 t237 0 0.161741p
Rt241 t237 tm239 0.0064915
Lt241 tm239 t240 0.872294n
Ct241 t240 0 0.161741p
Rt244 t240 tm242 0.0064915
Lt244 tm242 t243 0.872294n
Ct244 t243 0 0.161741p
Rt247 t243 tm245 0.0064915
Lt247 tm245 t246 0.872294n
Ct247 t246 0 0.161741p
Rt250 t246 tm248 0.0064915
Lt250 tm248 t249 0.872294n
Ct250 t249 0 0.161741p
Rt253 t249 tm251 0.0064915
Lt253 tm251 t252 0.872294n
Ct253 t252 0 0.161741p
Rt256 t252 tm254 0.0064915
Lt256 tm254 t255 0.872294n
Ct256 t255 0 0.161741p
Rt259 t255 tm257 0.0064915
Lt259 tm257 t258 0.872294n
Ct259 t258 0 0.161741p
Rt262 t258 tm260 0.0064915
Lt262 tm260 t261 0.872294n
Ct262 t261 0 0.161741p
Rt265 t261 tm263 0.0064915
Lt265 tm263 t264 0.872294n
Ct265 t264 0 0.161741p
Rt268 t264 tm266 0.0064915
Lt268 tm266 t267 0.872294n
Ct268 t267 0 0.161741p
Rt271 t267 tm269 0.0064915
Lt271 tm269 t270 0.872294n
Ct271 t270 0 0.161741p
Rt274 t270 tm272 0.0064915
Lt274 tm272 t273 0.872294n
Ct274 t273 0 0.161741p
Rt277 t273 tm275 0.0064915
Lt277 tm275 t276 0.872294n
Ct277 t276 0 0.161741p
Rt280 t276 tm278 0.0064915
Lt280 tm278 t279 0.872294n
Ct280 t279 0 0.161741p
Rt283 t279 tm281 0.0064915
Lt283 tm281 t282 0.872294n
Ct283 t282 0 0.161741p
Rt286 t282 tm284 0.0064915
Lt286 tm284 t285 0.872294n
Ct286 t285 0 0.161741p
Rt289 t285 tm287 0.0064915
Lt289 tm287 t288 0.872294n
Ct289 t288 0 0.161741p
Rt292 t288 tm290 0.0064915
Lt292 tm290 t291 0.872294n
Ct292 t291 0 0.161741p
Rt294 t291 tm293 0.0064915
Lt294 tm293 p76 0.872294n
Ct294 p76 0 0.161741p
Lv296 p76 v295 1.358n
Cv296 v295 0 0.4885p
Rt300 v295 tm298 0.0046778
Lt300 tm298 t299 0.628579n
Ct300 t299 0 0.116551p
Rt302 t299 tm301 0.0046778
Lt302 tm301 p297 0.628579n
Ct302 p297 0 0.116551p
Lv304 p297 v303 1.358n
Cv304 v303 0 0.4885p
Rt308 v303 tm306 0.00409042
Lt308 tm306 t307 0.549649n
Ct308 t307 0 0.101916p
Rt310 t307 tm309 0.00409042
Lt310 tm309 p305 0.549649n
Ct310 p305 0 0.101916p
Lv312 p305 v311 1.358n
Cv312 v311 0 0.4885p
Rt316 v311 tm314 0.00567519
Lt316 tm314 t315 0.762603n
Ct316 t315 0 0.141402p
Rt319 t315 tm317 0.00567519
Lt319 tm317 t318 0.762603n
Ct319 t318 0 0.141402p
Rt322 t318 tm320 0.00567519
Lt322 tm320 t321 0.762603n
Ct322 t321 0 0.141402p
Rt325 t321 tm323 0.00567519
Lt325 tm323 t324 0.762603n
Ct325 t324 0 0.141402p
Rt327 t324 tm326 0.00567519
Lt327 tm326 p313 0.762603n
Ct327 p313 0 0.141402p
Lv329 p313 v328 1.358n
Cv329 v328 0 0.4885p
Rt333 v328 tm331 0.00627863
Lt333 tm331 t332 0.84369n
Ct333 t332 0 0.156437p
Rt336 t332 tm334 0.00627863
Lt336 tm334 t335 0.84369n
Ct336 t335 0 0.156437p
Rt339 t335 tm337 0.00627863
Lt339 tm337 t338 0.84369n
Ct339 t338 0 0.156437p
Rt342 t338 tm340 0.00627863
Lt342 tm340 t341 0.84369n
Ct342 t341 0 0.156437p
Rt345 t341 tm343 0.00627863
Lt345 tm343 t344 0.84369n
Ct345 t344 0 0.156437p
Rt348 t344 tm346 0.00627863
Lt348 tm346 t347 0.84369n
Ct348 t347 0 0.156437p
Rt351 t347 tm349 0.00627863
Lt351 tm349 t350 0.84369n
Ct351 t350 0 0.156437p
Rt354 t350 tm352 0.00627863
Lt354 tm352 t353 0.84369n
Ct354 t353 0 0.156437p
Rt357 t353 tm355 0.00627863
Lt357 tm355 t356 0.84369n
Ct357 t356 0 0.156437p
Rt360 t356 tm358 0.00627863
Lt360 tm358 t359 0.84369n
Ct360 t359 0 0.156437p
Rt363 t359 tm361 0.00627863
Lt363 tm361 t362 0.84369n
Ct363 t362 0 0.156437p
Rt366 t362 tm364 0.00627863
Lt366 tm364 t365 0.84369n
Ct366 t365 0 0.156437p
Rt369 t365 tm367 0.00627863
Lt369 tm367 t368 0.84369n
Ct369 t368 0 0.156437p
Rt372 t368 tm370 0.00627863
Lt372 tm370 t371 0.84369n
Ct372 t371 0 0.156437p
Rt375 t371 tm373 0.00627863
Lt375 tm373 t374 0.84369n
Ct375 t374 0 0.156437p
Rt378 t374 tm376 0.00627863
Lt378 tm376 t377 0.84369n
Ct378 t377 0 0.156437p
Rt381 t377 tm379 0.00627863
Lt381 tm379 t380 0.84369n
Ct381 t380 0 0.156437p
Rt384 t380 tm382 0.00627863
Lt384 tm382 t383 0.84369n
Ct384 t383 0 0.156437p
Rt387 t383 tm385 0.00627863
Lt387 tm385 t386 0.84369n
Ct387 t386 0 0.156437p
Rt390 t386 tm388 0.00627863
Lt390 tm388 t389 0.84369n
Ct390 t389 0 0.156437p
Rt393 t389 tm391 0.00627863
Lt393 tm391 t392 0.84369n
Ct393 t392 0 0.156437p
Rt396 t392 tm394 0.00627863
Lt396 tm394 t395 0.84369n
Ct396 t395 0 0.156437p
Rt398 t395 tm397 0.00627863
Lt398 tm397 p330 0.84369n
Ct398 p330 0 0.156437p
Lv400 p330 v399 1.358n
Cv400 v399 0 0.4885p
Rt403 v399 tm401 0.0062357
Lt403 tm401 t402 0.837921n
Ct403 t402 0 0.155367p
Rt406 t402 tm404 0.0062357
Lt406 tm404 t405 0.837921n
Ct406 t405 0 0.155367p
Rt409 t405 tm407 0.0062357
Lt409 tm407 t408 0.837921n
Ct409 t408 0 0.155367p
Rt412 t408 tm410 0.0062357
Lt412 tm410 t411 0.837921n
Ct412 t411 0 0.155367p
Rt415 t411 tm413 0.0062357
Lt415 tm413 t414 0.837921n
Ct415 t414 0 0.155367p
Rt418 t414 tm416 0.0062357
Lt418 tm416 t417 0.837921n
Ct418 t417 0 0.155367p
Rt421 t417 tm419 0.0062357
Lt421 tm419 t420 0.837921n
Ct421 t420 0 0.155367p
Rt424 t420 tm422 0.0062357
Lt424 tm422 t423 0.837921n
Ct424 t423 0 0.155367p
Rt427 t423 tm425 0.0062357
Lt427 tm425 t426 0.837921n
Ct427 t426 0 0.155367p
Rt430 t426 tm428 0.0062357
Lt430 tm428 t429 0.837921n
Ct430 t429 0 0.155367p
Rt433 t429 tm431 0.0062357
Lt433 tm431 t432 0.837921n
Ct433 t432 0 0.155367p
Rt436 t432 tm434 0.0062357
Lt436 tm434 t435 0.837921n
Ct436 t435 0 0.155367p
Rt439 t435 tm437 0.0062357
Lt439 tm437 t438 0.837921n
Ct439 t438 0 0.155367p
Rt442 t438 tm440 0.0062357
Lt442 tm440 t441 0.837921n
Ct442 t441 0 0.155367p
Rt445 t441 tm443 0.0062357
Lt445 tm443 t444 0.837921n
Ct445 t444 0 0.155367p
Rt447 t444 tm446 0.0062357
Lt447 tm446 din 0.837921n
Ct447 din 0 0.155367p
Cin din 0 5p
.tran 0.1n 5000n 0 0.2n
.control
set wr_singlescale
set wr_vecnames
set numdgt=7
run

wrdata /out/led_hop00_nom.txt v(dout) v(din)
.endc
.end
