* USB full speed, device_tx, source ramp 8 ns, cable none
Vdp sp 0 PWL(0.0000n 3.3 329.3333n 3.3 337.3333n 0 412.6667n 0 420.6667n 3.3 496.0000n 3.3 504.0000n 0 579.3333n 0 587.3333n 3.3 662.6667n 3.3 670.6667n 0 746.0000n 0 754.0000n 3.3 829.3333n 3.3 837.3333n 0 996.0000n 0 1004.0000n 3.3 1079.3333n 3.3 1087.3333n 0 1329.3333n 0 1337.3333n 3.3 1496.0000n 3.3 1504.0000n 0 1579.3333n 0 1587.3333n 3.3 2162.6667n 3.3 2170.6667n 0 2246.0000n 0 2254.0000n 3.3 2329.3333n 3.3 2337.3333n 0 2912.6667n 0 2920.6667n 3.3 2996.0000n 3.3 3004.0000n 0 3079.3333n 0 3087.3333n 3.3 3246.0000n 3.3 3254.0000n 0 3412.6667n 0 3420.6667n 3.3 3662.6667n 3.3 3670.6667n 0 3996.0000n 0 4004.0000n 3.3 4079.3333n 3.3 4087.3333n 0 4162.6667n 0 4170.6667n 3.3 4579.3333n 3.3 4587.3333n 0 4662.6667n 0 4670.6667n 3.3 4746.0000n 3.3 4754.0000n 0 4912.6667n 0 4920.6667n 3.3 5079.3333n 3.3 5087.3333n 0 5162.6667n 0 5170.6667n 3.3)
Vdm sm 0 PWL(0.0000n 0 329.3333n 0 337.3333n 3.3 412.6667n 3.3 420.6667n 0 496.0000n 0 504.0000n 3.3 579.3333n 3.3 587.3333n 0 662.6667n 0 670.6667n 3.3 746.0000n 3.3 754.0000n 0 829.3333n 0 837.3333n 3.3 996.0000n 3.3 1004.0000n 0 1079.3333n 0 1087.3333n 3.3 1329.3333n 3.3 1337.3333n 0 1496.0000n 0 1504.0000n 3.3 1579.3333n 3.3 1587.3333n 0 2162.6667n 0 2170.6667n 3.3 2246.0000n 3.3 2254.0000n 0 2329.3333n 0 2337.3333n 3.3 2912.6667n 3.3 2920.6667n 0 2996.0000n 0 3004.0000n 3.3 3079.3333n 3.3 3087.3333n 0 3246.0000n 0 3254.0000n 3.3 3412.6667n 3.3 3420.6667n 0 3662.6667n 0 3670.6667n 3.3 3996.0000n 3.3 4004.0000n 0 4079.3333n 0 4087.3333n 3.3 4162.6667n 3.3 4170.6667n 0 4579.3333n 0 4587.3333n 3.3 4662.6667n 3.3 4670.6667n 0 4746.0000n 0 4754.0000n 3.3 4912.6667n 3.3 4920.6667n 0 5079.3333n 0 5087.3333n 3.3 5162.6667n 3.3 5170.6667n 0)
Rphyp sp pinp 9
Rphym sm pinm 9
Cpinp pinp 0 5p
Cpinm pinm 0 5p
Vpu vpu 0 3.3
Rpu vpu pinp 1.5k
Rt3 pinp tm1 0.00448183
Lt3 tm1 t2 0.602245n
Ct3 t2 0 0.111668p
Rt6 t2 tm4 0.00448183
Lt6 tm4 t5 0.602245n
Ct6 t5 0 0.111668p
Rt8 t5 tm7 0.00448183
Lt8 tm7 rp_a 0.602245n
Ct8 rp_a 0 0.111668p
Rt11 pinm tm9 0.00625752
Lt11 tm9 t10 0.840854n
Ct11 t10 0 0.155911p
Rt13 t10 tm12 0.00625752
Lt13 tm12 rm_a 0.840854n
Ct13 rm_a 0 0.155911p
R102 rp_a rp_b 27
R103 rm_a rm_b 27
Rt18 conp tm17 0.0030141
Lt18 tm17 u16 0.405019n
Ct18 u16 0 0.0750985p
Lv20 u16 u19 1.358n
Cv20 u19 0 0.4885p
Rt23 u19 tm21 0.00562666
Lt23 tm21 t22 0.756081n
Ct23 t22 0 0.140193p
Rt26 t22 tm24 0.00562666
Lt26 tm24 t25 0.756081n
Ct26 t25 0 0.140193p
Rt28 t25 tm27 0.00562666
Lt28 tm27 dp14 0.756081n
Ct28 dp14 0 0.140193p
Rt31 conm tm30 0.00582544
Lt31 tm30 u29 0.782792n
Ct31 u29 0 0.145145p
Lv33 u29 u32 1.358n
Cv33 u32 0 0.4885p
Rt36 u32 tm34 0.00468437
Lt36 tm34 t35 0.629461n
Ct36 t35 0 0.116715p
Rt39 t35 tm37 0.00468437
Lt39 tm37 t38 0.629461n
Ct39 t38 0 0.116715p
Rt41 t38 tm40 0.00468437
Lt41 tm40 dm15 0.629461n
Ct41 dm15 0 0.116715p
Rp1a48 dp14 p1ra49 0.00578857
Rp1b48 dm15 p1rb50 0.00578857
Lp1a48 p1ra49 p1a46 1.03896n
Lp1b48 p1rb50 p1b47 1.03896n
Kp148 Lp1a48 Lp1b48 0.22195
Cp1a48 p1a46 0 0.267628p
Cp1b48 p1b47 0 0.267628p
Cp1m48 p1a46 p1b47 0.0448628p
Rp1a53 p1a46 p1ra54 0.00578857
Rp1b53 p1b47 p1rb55 0.00578857
Lp1a53 p1ra54 p1a51 1.03896n
Lp1b53 p1rb55 p1b52 1.03896n
Kp153 Lp1a53 Lp1b53 0.22195
Cp1a53 p1a51 0 0.267628p
Cp1b53 p1b52 0 0.267628p
Cp1m53 p1a51 p1b52 0.0448628p
Rp1a58 p1a51 p1ra59 0.00578857
Rp1b58 p1b52 p1rb60 0.00578857
Lp1a58 p1ra59 p1a56 1.03896n
Lp1b58 p1rb60 p1b57 1.03896n
Kp158 Lp1a58 Lp1b58 0.22195
Cp1a58 p1a56 0 0.267628p
Cp1b58 p1b57 0 0.267628p
Cp1m58 p1a56 p1b57 0.0448628p
Rp1a63 p1a56 p1ra64 0.00578857
Rp1b63 p1b57 p1rb65 0.00578857
Lp1a63 p1ra64 p1a61 1.03896n
Lp1b63 p1rb65 p1b62 1.03896n
Kp163 Lp1a63 Lp1b63 0.22195
Cp1a63 p1a61 0 0.267628p
Cp1b63 p1b62 0 0.267628p
Cp1m63 p1a61 p1b62 0.0448628p
Rp1a68 p1a61 p1ra69 0.00578857
Rp1b68 p1b62 p1rb70 0.00578857
Lp1a68 p1ra69 p1a66 1.03896n
Lp1b68 p1rb70 p1b67 1.03896n
Kp168 Lp1a68 Lp1b68 0.22195
Cp1a68 p1a66 0 0.267628p
Cp1b68 p1b67 0 0.267628p
Cp1m68 p1a66 p1b67 0.0448628p
Rp1a73 p1a66 p1ra74 0.00578857
Rp1b73 p1b67 p1rb75 0.00578857
Lp1a73 p1ra74 p1a71 1.03896n
Lp1b73 p1rb75 p1b72 1.03896n
Kp173 Lp1a73 Lp1b73 0.22195
Cp1a73 p1a71 0 0.267628p
Cp1b73 p1b72 0 0.267628p
Cp1m73 p1a71 p1b72 0.0448628p
Rp1a78 p1a71 p1ra79 0.00578857
Rp1b78 p1b72 p1rb80 0.00578857
Lp1a78 p1ra79 p1a76 1.03896n
Lp1b78 p1rb80 p1b77 1.03896n
Kp178 Lp1a78 Lp1b78 0.22195
Cp1a78 p1a76 0 0.267628p
Cp1b78 p1b77 0 0.267628p
Cp1m78 p1a76 p1b77 0.0448628p
Rp1a83 p1a76 p1ra84 0.00578857
Rp1b83 p1b77 p1rb85 0.00578857
Lp1a83 p1ra84 p1a81 1.03896n
Lp1b83 p1rb85 p1b82 1.03896n
Kp183 Lp1a83 Lp1b83 0.22195
Cp1a83 p1a81 0 0.267628p
Cp1b83 p1b82 0 0.267628p
Cp1m83 p1a81 p1b82 0.0448628p
Rp1a88 p1a81 p1ra89 0.00578857
Rp1b88 p1b82 p1rb90 0.00578857
Lp1a88 p1ra89 p1a86 1.03896n
Lp1b88 p1rb90 p1b87 1.03896n
Kp188 Lp1a88 Lp1b88 0.22195
Cp1a88 p1a86 0 0.267628p
Cp1b88 p1b87 0 0.267628p
Cp1m88 p1a86 p1b87 0.0448628p
Rp1a93 p1a86 p1ra94 0.00578857
Rp1b93 p1b87 p1rb95 0.00578857
Lp1a93 p1ra94 p1a91 1.03896n
Lp1b93 p1rb95 p1b92 1.03896n
Kp193 Lp1a93 Lp1b93 0.22195
Cp1a93 p1a91 0 0.267628p
Cp1b93 p1b92 0 0.267628p
Cp1m93 p1a91 p1b92 0.0448628p
Rp1a98 p1a91 p1ra99 0.00578857
Rp1b98 p1b92 p1rb100 0.00578857
Lp1a98 p1ra99 p1a96 1.03896n
Lp1b98 p1rb100 p1b97 1.03896n
Kp198 Lp1a98 Lp1b98 0.22195
Cp1a98 p1a96 0 0.267628p
Cp1b98 p1b97 0 0.267628p
Cp1m98 p1a96 p1b97 0.0448628p
Rp1a103 p1a96 p1ra104 0.00578857
Rp1b103 p1b97 p1rb105 0.00578857
Lp1a103 p1ra104 p1a101 1.03896n
Lp1b103 p1rb105 p1b102 1.03896n
Kp1103 Lp1a103 Lp1b103 0.22195
Cp1a103 p1a101 0 0.267628p
Cp1b103 p1b102 0 0.267628p
Cp1m103 p1a101 p1b102 0.0448628p
Rp1a106 p1a101 p1ra107 0.00578857
Rp1b106 p1b102 p1rb108 0.00578857
Lp1a106 p1ra107 dpx44 1.03896n
Lp1b106 p1rb108 dmx45 1.03896n
Kp1106 Lp1a106 Lp1b106 0.22195
Cp1a106 dpx44 0 0.267628p
Cp1b106 dmx45 0 0.267628p
Cp1m106 dpx44 dmx45 0.0448628p
Rt110 dpx44 tm109 9.08444e-06
Lt110 tm109 dp42 0.00165058n
Ct110 dp42 0 0.000475437p
Rj111 dmx45 dm43 1m
Lv114 dp42 dp112 1.358n
Cv114 dp112 0 0.4885p
Lv115 dm43 dm113 1.358n
Cv115 dm113 0 0.4885p
Rp3a122 dp112 p3ra123 0.0057538
Rp3b122 dm113 p3rb124 0.0057538
Lp3a122 p3ra123 p3a120 1.03272n
Lp3b122 p3rb124 p3b121 1.03272n
Kp3122 Lp3a122 Lp3b122 0.22195
Cp3a122 p3a120 0 0.26602p
Cp3b122 p3b121 0 0.26602p
Cp3m122 p3a120 p3b121 0.0445933p
Rp3a127 p3a120 p3ra128 0.0057538
Rp3b127 p3b121 p3rb129 0.0057538
Lp3a127 p3ra128 p3a125 1.03272n
Lp3b127 p3rb129 p3b126 1.03272n
Kp3127 Lp3a127 Lp3b127 0.22195
Cp3a127 p3a125 0 0.26602p
Cp3b127 p3b126 0 0.26602p
Cp3m127 p3a125 p3b126 0.0445933p
Rp3a132 p3a125 p3ra133 0.0057538
Rp3b132 p3b126 p3rb134 0.0057538
Lp3a132 p3ra133 p3a130 1.03272n
Lp3b132 p3rb134 p3b131 1.03272n
Kp3132 Lp3a132 Lp3b132 0.22195
Cp3a132 p3a130 0 0.26602p
Cp3b132 p3b131 0 0.26602p
Cp3m132 p3a130 p3b131 0.0445933p
Rp3a137 p3a130 p3ra138 0.0057538
Rp3b137 p3b131 p3rb139 0.0057538
Lp3a137 p3ra138 p3a135 1.03272n
Lp3b137 p3rb139 p3b136 1.03272n
Kp3137 Lp3a137 Lp3b137 0.22195
Cp3a137 p3a135 0 0.26602p
Cp3b137 p3b136 0 0.26602p
Cp3m137 p3a135 p3b136 0.0445933p
Rp3a142 p3a135 p3ra143 0.0057538
Rp3b142 p3b136 p3rb144 0.0057538
Lp3a142 p3ra143 p3a140 1.03272n
Lp3b142 p3rb144 p3b141 1.03272n
Kp3142 Lp3a142 Lp3b142 0.22195
Cp3a142 p3a140 0 0.26602p
Cp3b142 p3b141 0 0.26602p
Cp3m142 p3a140 p3b141 0.0445933p
Rp3a147 p3a140 p3ra148 0.0057538
Rp3b147 p3b141 p3rb149 0.0057538
Lp3a147 p3ra148 p3a145 1.03272n
Lp3b147 p3rb149 p3b146 1.03272n
Kp3147 Lp3a147 Lp3b147 0.22195
Cp3a147 p3a145 0 0.26602p
Cp3b147 p3b146 0 0.26602p
Cp3m147 p3a145 p3b146 0.0445933p
Rp3a152 p3a145 p3ra153 0.0057538
Rp3b152 p3b146 p3rb154 0.0057538
Lp3a152 p3ra153 p3a150 1.03272n
Lp3b152 p3rb154 p3b151 1.03272n
Kp3152 Lp3a152 Lp3b152 0.22195
Cp3a152 p3a150 0 0.26602p
Cp3b152 p3b151 0 0.26602p
Cp3m152 p3a150 p3b151 0.0445933p
Rp3a157 p3a150 p3ra158 0.0057538
Rp3b157 p3b151 p3rb159 0.0057538
Lp3a157 p3ra158 p3a155 1.03272n
Lp3b157 p3rb159 p3b156 1.03272n
Kp3157 Lp3a157 Lp3b157 0.22195
Cp3a157 p3a155 0 0.26602p
Cp3b157 p3b156 0 0.26602p
Cp3m157 p3a155 p3b156 0.0445933p
Rp3a162 p3a155 p3ra163 0.0057538
Rp3b162 p3b156 p3rb164 0.0057538
Lp3a162 p3ra163 p3a160 1.03272n
Lp3b162 p3rb164 p3b161 1.03272n
Kp3162 Lp3a162 Lp3b162 0.22195
Cp3a162 p3a160 0 0.26602p
Cp3b162 p3b161 0 0.26602p
Cp3m162 p3a160 p3b161 0.0445933p
Rp3a167 p3a160 p3ra168 0.0057538
Rp3b167 p3b161 p3rb169 0.0057538
Lp3a167 p3ra168 p3a165 1.03272n
Lp3b167 p3rb169 p3b166 1.03272n
Kp3167 Lp3a167 Lp3b167 0.22195
Cp3a167 p3a165 0 0.26602p
Cp3b167 p3b166 0 0.26602p
Cp3m167 p3a165 p3b166 0.0445933p
Rp3a172 p3a165 p3ra173 0.0057538
Rp3b172 p3b166 p3rb174 0.0057538
Lp3a172 p3ra173 p3a170 1.03272n
Lp3b172 p3rb174 p3b171 1.03272n
Kp3172 Lp3a172 Lp3b172 0.22195
Cp3a172 p3a170 0 0.26602p
Cp3b172 p3b171 0 0.26602p
Cp3m172 p3a170 p3b171 0.0445933p
Rp3a177 p3a170 p3ra178 0.0057538
Rp3b177 p3b171 p3rb179 0.0057538
Lp3a177 p3ra178 p3a175 1.03272n
Lp3b177 p3rb179 p3b176 1.03272n
Kp3177 Lp3a177 Lp3b177 0.22195
Cp3a177 p3a175 0 0.26602p
Cp3b177 p3b176 0 0.26602p
Cp3m177 p3a175 p3b176 0.0445933p
Rp3a182 p3a175 p3ra183 0.0057538
Rp3b182 p3b176 p3rb184 0.0057538
Lp3a182 p3ra183 p3a180 1.03272n
Lp3b182 p3rb184 p3b181 1.03272n
Kp3182 Lp3a182 Lp3b182 0.22195
Cp3a182 p3a180 0 0.26602p
Cp3b182 p3b181 0 0.26602p
Cp3m182 p3a180 p3b181 0.0445933p
Rp3a187 p3a180 p3ra188 0.0057538
Rp3b187 p3b181 p3rb189 0.0057538
Lp3a187 p3ra188 p3a185 1.03272n
Lp3b187 p3rb189 p3b186 1.03272n
Kp3187 Lp3a187 Lp3b187 0.22195
Cp3a187 p3a185 0 0.26602p
Cp3b187 p3b186 0 0.26602p
Cp3m187 p3a185 p3b186 0.0445933p
Rp3a192 p3a185 p3ra193 0.0057538
Rp3b192 p3b186 p3rb194 0.0057538
Lp3a192 p3ra193 p3a190 1.03272n
Lp3b192 p3rb194 p3b191 1.03272n
Kp3192 Lp3a192 Lp3b192 0.22195
Cp3a192 p3a190 0 0.26602p
Cp3b192 p3b191 0 0.26602p
Cp3m192 p3a190 p3b191 0.0445933p
Rp3a197 p3a190 p3ra198 0.0057538
Rp3b197 p3b191 p3rb199 0.0057538
Lp3a197 p3ra198 p3a195 1.03272n
Lp3b197 p3rb199 p3b196 1.03272n
Kp3197 Lp3a197 Lp3b197 0.22195
Cp3a197 p3a195 0 0.26602p
Cp3b197 p3b196 0 0.26602p
Cp3m197 p3a195 p3b196 0.0445933p
Rp3a202 p3a195 p3ra203 0.0057538
Rp3b202 p3b196 p3rb204 0.0057538
Lp3a202 p3ra203 p3a200 1.03272n
Lp3b202 p3rb204 p3b201 1.03272n
Kp3202 Lp3a202 Lp3b202 0.22195
Cp3a202 p3a200 0 0.26602p
Cp3b202 p3b201 0 0.26602p
Cp3m202 p3a200 p3b201 0.0445933p
Rp3a207 p3a200 p3ra208 0.0057538
Rp3b207 p3b201 p3rb209 0.0057538
Lp3a207 p3ra208 p3a205 1.03272n
Lp3b207 p3rb209 p3b206 1.03272n
Kp3207 Lp3a207 Lp3b207 0.22195
Cp3a207 p3a205 0 0.26602p
Cp3b207 p3b206 0 0.26602p
Cp3m207 p3a205 p3b206 0.0445933p
Rp3a212 p3a205 p3ra213 0.0057538
Rp3b212 p3b206 p3rb214 0.0057538
Lp3a212 p3ra213 p3a210 1.03272n
Lp3b212 p3rb214 p3b211 1.03272n
Kp3212 Lp3a212 Lp3b212 0.22195
Cp3a212 p3a210 0 0.26602p
Cp3b212 p3b211 0 0.26602p
Cp3m212 p3a210 p3b211 0.0445933p
Rp3a217 p3a210 p3ra218 0.0057538
Rp3b217 p3b211 p3rb219 0.0057538
Lp3a217 p3ra218 p3a215 1.03272n
Lp3b217 p3rb219 p3b216 1.03272n
Kp3217 Lp3a217 Lp3b217 0.22195
Cp3a217 p3a215 0 0.26602p
Cp3b217 p3b216 0 0.26602p
Cp3m217 p3a215 p3b216 0.0445933p
Rp3a222 p3a215 p3ra223 0.0057538
Rp3b222 p3b216 p3rb224 0.0057538
Lp3a222 p3ra223 p3a220 1.03272n
Lp3b222 p3rb224 p3b221 1.03272n
Kp3222 Lp3a222 Lp3b222 0.22195
Cp3a222 p3a220 0 0.26602p
Cp3b222 p3b221 0 0.26602p
Cp3m222 p3a220 p3b221 0.0445933p
Rp3a227 p3a220 p3ra228 0.0057538
Rp3b227 p3b221 p3rb229 0.0057538
Lp3a227 p3ra228 p3a225 1.03272n
Lp3b227 p3rb229 p3b226 1.03272n
Kp3227 Lp3a227 Lp3b227 0.22195
Cp3a227 p3a225 0 0.26602p
Cp3b227 p3b226 0 0.26602p
Cp3m227 p3a225 p3b226 0.0445933p
Rp3a232 p3a225 p3ra233 0.0057538
Rp3b232 p3b226 p3rb234 0.0057538
Lp3a232 p3ra233 p3a230 1.03272n
Lp3b232 p3rb234 p3b231 1.03272n
Kp3232 Lp3a232 Lp3b232 0.22195
Cp3a232 p3a230 0 0.26602p
Cp3b232 p3b231 0 0.26602p
Cp3m232 p3a230 p3b231 0.0445933p
Rp3a237 p3a230 p3ra238 0.0057538
Rp3b237 p3b231 p3rb239 0.0057538
Lp3a237 p3ra238 p3a235 1.03272n
Lp3b237 p3rb239 p3b236 1.03272n
Kp3237 Lp3a237 Lp3b237 0.22195
Cp3a237 p3a235 0 0.26602p
Cp3b237 p3b236 0 0.26602p
Cp3m237 p3a235 p3b236 0.0445933p
Rp3a242 p3a235 p3ra243 0.0057538
Rp3b242 p3b236 p3rb244 0.0057538
Lp3a242 p3ra243 p3a240 1.03272n
Lp3b242 p3rb244 p3b241 1.03272n
Kp3242 Lp3a242 Lp3b242 0.22195
Cp3a242 p3a240 0 0.26602p
Cp3b242 p3b241 0 0.26602p
Cp3m242 p3a240 p3b241 0.0445933p
Rp3a245 p3a240 p3ra246 0.0057538
Rp3b245 p3b241 p3rb247 0.0057538
Lp3a245 p3ra246 dpx118 1.03272n
Lp3b245 p3rb247 dmx119 1.03272n
Kp3245 Lp3a245 Lp3b245 0.22195
Cp3a245 dpx118 0 0.26602p
Cp3b245 dmx119 0 0.26602p
Cp3m245 dpx118 dmx119 0.0445933p
Rj248 dpx118 dp116 1m
Rt250 dmx119 tm249 3.33044e-05
Lt250 tm249 dm117 0.00605117n
Ct250 dm117 0 0.00174299p
Rt255 dp116 tm254 0.00643789
Lt255 tm254 u253 0.86509n
Ct255 u253 0 0.160405p
Lv257 u253 u256 1.358n
Cv257 u256 0 0.4885p
Rt260 u256 tm258 0.0033742
Lt260 tm258 t259 0.453408n
Ct260 t259 0 0.0840709p
Rt262 t259 tm261 0.0033742
Lt262 tm261 dp251 0.453408n
Ct262 dp251 0 0.0840709p
Rt265 dm117 tm264 0.00628268
Lt265 tm264 u263 0.844235n
Ct265 u263 0 0.156538p
Lv267 u263 u266 1.358n
Cv267 u266 0 0.4885p
Rt269 u266 tm268 0.00627529
Lt269 tm268 dm252 0.843241n
Ct269 dm252 0 0.156354p
Rp5a276 dp251 p5ra277 0.00469128
Rp5b276 dm252 p5rb278 0.00469128
Lp5a276 p5ra277 p5a274 0.842013n
Lp5b276 p5rb278 p5b275 0.842013n
Kp5276 Lp5a276 Lp5b276 0.22195
Cp5a276 p5a274 0 0.216896p
Cp5b276 p5b275 0 0.216896p
Cp5m276 p5a274 p5b275 0.0363586p
Rp5a281 p5a274 p5ra282 0.00469128
Rp5b281 p5b275 p5rb283 0.00469128
Lp5a281 p5ra282 p5a279 0.842013n
Lp5b281 p5rb283 p5b280 0.842013n
Kp5281 Lp5a281 Lp5b281 0.22195
Cp5a281 p5a279 0 0.216896p
Cp5b281 p5b280 0 0.216896p
Cp5m281 p5a279 p5b280 0.0363586p
Rp5a286 p5a279 p5ra287 0.00469128
Rp5b286 p5b280 p5rb288 0.00469128
Lp5a286 p5ra287 p5a284 0.842013n
Lp5b286 p5rb288 p5b285 0.842013n
Kp5286 Lp5a286 Lp5b286 0.22195
Cp5a286 p5a284 0 0.216896p
Cp5b286 p5b285 0 0.216896p
Cp5m286 p5a284 p5b285 0.0363586p
Rp5a289 p5a284 p5ra290 0.00469128
Rp5b289 p5b285 p5rb291 0.00469128
Lp5a289 p5ra290 dpx272 0.842013n
Lp5b289 p5rb291 dmx273 0.842013n
Kp5289 Lp5a289 Lp5b289 0.22195
Cp5a289 dpx272 0 0.216896p
Cp5b289 dmx273 0 0.216896p
Cp5m289 dpx272 dmx273 0.0363586p
Rt293 dpx272 tm292 0.00142884
Lt293 tm292 dp270 0.259609n
Ct293 dp270 0 0.0747786p
Rj294 dmx273 dm271 1m
Lv297 dp270 dp295 1.358n
Cv297 dp295 0 0.4885p
Lv298 dm271 dm296 1.358n
Cv298 dm296 0 0.4885p
Rp7a303 dp295 p7ra304 0.003075
Rp7b303 dm296 p7rb305 0.003075
Lp7a303 p7ra304 p7a301 0.551916n
Lp7b303 p7rb305 p7b302 0.551916n
Kp7303 Lp7a303 Lp7b303 0.22195
Cp7a303 p7a301 0 0.142169p
Cp7b303 p7b302 0 0.142169p
Cp7m303 p7a301 p7b302 0.023832p
Rp7a306 p7a301 p7ra307 0.003075
Rp7b306 p7b302 p7rb308 0.003075
Lp7a306 p7ra307 dpx299 0.551916n
Lp7b306 p7rb308 dmx300 0.551916n
Kp7306 Lp7a306 Lp7b306 0.22195
Cp7a306 dpx299 0 0.142169p
Cp7b306 dmx300 0 0.142169p
Cp7m306 dpx299 dmx300 0.023832p
Rt310 dpx299 tm309 0.00118725
Lt310 tm309 rp_b 0.215715n
Ct310 rp_b 0 0.0621352p
Rj311 dmx300 rm_b 1m
Cu10p conp 0 0.7p
Cu10m conm 0 0.7p
Rst315 conp stm313 0.00551383
Lst315 stm313 st314 0.74092n
Cst315 st314 0 0.137381p
Rst318 st314 stm316 0.00551383
Lst318 stm316 st317 0.74092n
Cst318 st317 0 0.137381p
Rst320 st317 stm319 0.00551383
Lst320 stm319 st312 0.74092n
Cst320 st312 0 0.137381p
Cst321 st312 0 0.3p
Rst325 conm stm323 0.00551164
Lst325 stm323 st324 0.740626n
Cst325 st324 0 0.137327p
Rst328 st324 stm326 0.00551164
Lst328 stm326 st327 0.740626n
Cst328 st327 0 0.137327p
Rst330 st327 stm329 0.00551164
Lst330 stm329 st322 0.740626n
Cst330 st322 0 0.137327p
Cst331 st322 0 0.3p
Cconp conp 0 0.6p
Cconm conm 0 0.6p
Clp conp 0 50p
Clm conm 0 50p
Rlp conp 0 15k
Rlm conm 0 15k
.options method=gear reltol=2e-3
.tran 0.1n 5333.3n 0 0.2n
.control
set wr_singlescale
set wr_vecnames
set numdgt=7
run

wrdata /out/usb_01_device_tx_8ns.txt v(conp) v(conm) v(conp) v(conm)
.endc
.end
