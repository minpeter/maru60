* USB full speed, device_tx, source ramp 4 ns, cable none
Vdp sp 0 PWL(0.0000n 3.3 331.3333n 3.3 335.3333n 0 414.6667n 0 418.6667n 3.3 498.0000n 3.3 502.0000n 0 581.3333n 0 585.3333n 3.3 664.6667n 3.3 668.6667n 0 748.0000n 0 752.0000n 3.3 831.3333n 3.3 835.3333n 0 998.0000n 0 1002.0000n 3.3 1081.3333n 3.3 1085.3333n 0 1331.3333n 0 1335.3333n 3.3 1498.0000n 3.3 1502.0000n 0 1581.3333n 0 1585.3333n 3.3 2164.6667n 3.3 2168.6667n 0 2248.0000n 0 2252.0000n 3.3 2331.3333n 3.3 2335.3333n 0 2914.6667n 0 2918.6667n 3.3 2998.0000n 3.3 3002.0000n 0 3081.3333n 0 3085.3333n 3.3 3248.0000n 3.3 3252.0000n 0 3414.6667n 0 3418.6667n 3.3 3664.6667n 3.3 3668.6667n 0 3998.0000n 0 4002.0000n 3.3 4081.3333n 3.3 4085.3333n 0 4164.6667n 0 4168.6667n 3.3 4581.3333n 3.3 4585.3333n 0 4664.6667n 0 4668.6667n 3.3 4748.0000n 3.3 4752.0000n 0 4914.6667n 0 4918.6667n 3.3 5081.3333n 3.3 5085.3333n 0 5164.6667n 0 5168.6667n 3.3)
Vdm sm 0 PWL(0.0000n 0 331.3333n 0 335.3333n 3.3 414.6667n 3.3 418.6667n 0 498.0000n 0 502.0000n 3.3 581.3333n 3.3 585.3333n 0 664.6667n 0 668.6667n 3.3 748.0000n 3.3 752.0000n 0 831.3333n 0 835.3333n 3.3 998.0000n 3.3 1002.0000n 0 1081.3333n 0 1085.3333n 3.3 1331.3333n 3.3 1335.3333n 0 1498.0000n 0 1502.0000n 3.3 1581.3333n 3.3 1585.3333n 0 2164.6667n 0 2168.6667n 3.3 2248.0000n 3.3 2252.0000n 0 2331.3333n 0 2335.3333n 3.3 2914.6667n 3.3 2918.6667n 0 2998.0000n 0 3002.0000n 3.3 3081.3333n 3.3 3085.3333n 0 3248.0000n 0 3252.0000n 3.3 3414.6667n 3.3 3418.6667n 0 3664.6667n 0 3668.6667n 3.3 3998.0000n 3.3 4002.0000n 0 4081.3333n 0 4085.3333n 3.3 4164.6667n 3.3 4168.6667n 0 4581.3333n 0 4585.3333n 3.3 4664.6667n 3.3 4668.6667n 0 4748.0000n 0 4752.0000n 3.3 4914.6667n 3.3 4918.6667n 0 5081.3333n 0 5085.3333n 3.3 5164.6667n 3.3 5168.6667n 0)
Rphyp sp pinp 9
Rphym sm pinm 9
Cpinp pinp 0 5p
Cpinm pinm 0 5p
Vpu vpu 0 3.3
Rpu vpu pinp 1.5k
Rt3 pinp tm1 0.00437464
Lt3 tm1 t2 0.587841n
Ct3 t2 0 0.108998p
Rt6 t2 tm4 0.00437464
Lt6 tm4 t5 0.587841n
Ct6 t5 0 0.108998p
Rt8 t5 tm7 0.00437464
Lt8 tm7 rp_a 0.587841n
Ct8 rp_a 0 0.108998p
Rt11 pinm tm10 0.00298827
Lt11 tm10 phy9 0.401549n
Ct11 phy9 0 0.0744552p
Lv13 phy9 phy12 1.358n
Cv13 phy12 0 0.4885p
Rt17 phy12 tm15 0.00570972
Lt17 tm15 t16 0.767242n
Ct17 t16 0 0.142262p
Rt20 t16 tm18 0.00570972
Lt20 tm18 t19 0.767242n
Ct20 t19 0 0.142262p
Rt22 t19 tm21 0.00570972
Lt22 tm21 phy14 0.767242n
Ct22 phy14 0 0.142262p
Lv24 phy14 phy23 1.358n
Cv24 phy23 0 0.4885p
Rt26 phy23 tm25 0.00195699
Lt26 tm25 rm_a 0.26297n
Ct26 rm_a 0 0.0487599p
R102 rp_a rp_b 27
R103 rm_a rm_b 27
Rt31 conp tm30 0.0030141
Lt31 tm30 u29 0.405019n
Ct31 u29 0 0.0750985p
Lv33 u29 u32 1.358n
Cv33 u32 0 0.4885p
Rt36 u32 tm34 0.00352901
Lt36 tm34 t35 0.474211n
Ct36 t35 0 0.0879281p
Rt38 t35 tm37 0.00352901
Lt38 tm37 dp27 0.474211n
Ct38 dp27 0 0.0879281p
Rt41 conm tm40 0.00582544
Lt41 tm40 u39 0.782792n
Ct41 u39 0 0.145145p
Lv42 u39 dm28 1.358n
Cv42 dm28 0 0.4885p
Rp1a49 dp27 p1ra50 0.00498468
Rp1b49 dm28 p1rb51 0.00498468
Lp1a49 p1ra50 p1a47 0.894673n
Lp1b49 p1rb51 p1b48 0.894673n
Kp149 Lp1a49 Lp1b49 0.22195
Cp1a49 p1a47 0 0.230461p
Cp1b49 p1b48 0 0.230461p
Cp1m49 p1a47 p1b48 0.0386324p
Rp1a54 p1a47 p1ra55 0.00498468
Rp1b54 p1b48 p1rb56 0.00498468
Lp1a54 p1ra55 p1a52 0.894673n
Lp1b54 p1rb56 p1b53 0.894673n
Kp154 Lp1a54 Lp1b54 0.22195
Cp1a54 p1a52 0 0.230461p
Cp1b54 p1b53 0 0.230461p
Cp1m54 p1a52 p1b53 0.0386324p
Rp1a59 p1a52 p1ra60 0.00498468
Rp1b59 p1b53 p1rb61 0.00498468
Lp1a59 p1ra60 p1a57 0.894673n
Lp1b59 p1rb61 p1b58 0.894673n
Kp159 Lp1a59 Lp1b59 0.22195
Cp1a59 p1a57 0 0.230461p
Cp1b59 p1b58 0 0.230461p
Cp1m59 p1a57 p1b58 0.0386324p
Rp1a64 p1a57 p1ra65 0.00498468
Rp1b64 p1b58 p1rb66 0.00498468
Lp1a64 p1ra65 p1a62 0.894673n
Lp1b64 p1rb66 p1b63 0.894673n
Kp164 Lp1a64 Lp1b64 0.22195
Cp1a64 p1a62 0 0.230461p
Cp1b64 p1b63 0 0.230461p
Cp1m64 p1a62 p1b63 0.0386324p
Rp1a67 p1a62 p1ra68 0.00498468
Rp1b67 p1b63 p1rb69 0.00498468
Lp1a67 p1ra68 dpx45 0.894673n
Lp1b67 p1rb69 dmx46 0.894673n
Kp167 Lp1a67 Lp1b67 0.22195
Cp1a67 dpx45 0 0.230461p
Cp1b67 dmx46 0 0.230461p
Cp1m67 dpx45 dmx46 0.0386324p
Rt71 dpx45 tm70 0.000557144
Lt71 tm70 dp43 0.101229n
Ct71 dp43 0 0.0291583p
Rj72 dmx46 dm44 1m
Lv75 dp43 dp73 1.358n
Cv75 dp73 0 0.4885p
Lv76 dm44 dm74 1.358n
Cv76 dm74 0 0.4885p
Rp3a83 dp73 p3ra84 0.00459922
Rp3b83 dm74 p3rb85 0.00459922
Lp3a83 p3ra84 p3a81 0.825489n
Lp3b83 p3rb85 p3b82 0.825489n
Kp383 Lp3a83 Lp3b83 0.22195
Cp3a83 p3a81 0 0.212639p
Cp3b83 p3b82 0 0.212639p
Cp3m83 p3a81 p3b82 0.035645p
Rp3a88 p3a81 p3ra89 0.00459922
Rp3b88 p3b82 p3rb90 0.00459922
Lp3a88 p3ra89 p3a86 0.825489n
Lp3b88 p3rb90 p3b87 0.825489n
Kp388 Lp3a88 Lp3b88 0.22195
Cp3a88 p3a86 0 0.212639p
Cp3b88 p3b87 0 0.212639p
Cp3m88 p3a86 p3b87 0.035645p
Rp3a91 p3a86 p3ra92 0.00459922
Rp3b91 p3b87 p3rb93 0.00459922
Lp3a91 p3ra92 dpx79 0.825489n
Lp3b91 p3rb93 dmx80 0.825489n
Kp391 Lp3a91 Lp3b91 0.22195
Cp3a91 dpx79 0 0.212639p
Cp3b91 dmx80 0 0.212639p
Cp3m91 dpx79 dmx80 0.035645p
Rj94 dpx79 dp77 1m
Rt96 dmx80 tm95 0.000544267
Lt96 tm95 dm78 0.0988895n
Ct96 dm78 0 0.0284844p
Lv99 dp77 dp97 1.358n
Cv99 dp97 0 0.4885p
Lv100 dm78 dm98 1.358n
Cv100 dm98 0 0.4885p
Rp5a107 dp97 p5ra108 0.00542598
Rp5b107 dm98 p5rb109 0.00542598
Lp5a107 p5ra108 p5a105 0.97388n
Lp5b107 p5rb109 p5b106 0.97388n
Kp5107 Lp5a107 Lp5b107 0.22195
Cp5a107 p5a105 0 0.250864p
Cp5b107 p5b106 0 0.250864p
Cp5m107 p5a105 p5b106 0.0420527p
Rp5a112 p5a105 p5ra113 0.00542598
Rp5b112 p5b106 p5rb114 0.00542598
Lp5a112 p5ra113 p5a110 0.97388n
Lp5b112 p5rb114 p5b111 0.97388n
Kp5112 Lp5a112 Lp5b112 0.22195
Cp5a112 p5a110 0 0.250864p
Cp5b112 p5b111 0 0.250864p
Cp5m112 p5a110 p5b111 0.0420527p
Rp5a117 p5a110 p5ra118 0.00542598
Rp5b117 p5b111 p5rb119 0.00542598
Lp5a117 p5ra118 p5a115 0.97388n
Lp5b117 p5rb119 p5b116 0.97388n
Kp5117 Lp5a117 Lp5b117 0.22195
Cp5a117 p5a115 0 0.250864p
Cp5b117 p5b116 0 0.250864p
Cp5m117 p5a115 p5b116 0.0420527p
Rp5a122 p5a115 p5ra123 0.00542598
Rp5b122 p5b116 p5rb124 0.00542598
Lp5a122 p5ra123 p5a120 0.97388n
Lp5b122 p5rb124 p5b121 0.97388n
Kp5122 Lp5a122 Lp5b122 0.22195
Cp5a122 p5a120 0 0.250864p
Cp5b122 p5b121 0 0.250864p
Cp5m122 p5a120 p5b121 0.0420527p
Rp5a127 p5a120 p5ra128 0.00542598
Rp5b127 p5b121 p5rb129 0.00542598
Lp5a127 p5ra128 p5a125 0.97388n
Lp5b127 p5rb129 p5b126 0.97388n
Kp5127 Lp5a127 Lp5b127 0.22195
Cp5a127 p5a125 0 0.250864p
Cp5b127 p5b126 0 0.250864p
Cp5m127 p5a125 p5b126 0.0420527p
Rp5a132 p5a125 p5ra133 0.00542598
Rp5b132 p5b126 p5rb134 0.00542598
Lp5a132 p5ra133 p5a130 0.97388n
Lp5b132 p5rb134 p5b131 0.97388n
Kp5132 Lp5a132 Lp5b132 0.22195
Cp5a132 p5a130 0 0.250864p
Cp5b132 p5b131 0 0.250864p
Cp5m132 p5a130 p5b131 0.0420527p
Rp5a135 p5a130 p5ra136 0.00542598
Rp5b135 p5b131 p5rb137 0.00542598
Lp5a135 p5ra136 dpx103 0.97388n
Lp5b135 p5rb137 dmx104 0.97388n
Kp5135 Lp5a135 Lp5b135 0.22195
Cp5a135 dpx103 0 0.250864p
Cp5b135 dmx104 0 0.250864p
Cp5m135 dpx103 dmx104 0.0420527p
Rt139 dpx103 tm138 0.000628371
Lt139 tm138 dp101 0.114171n
Ct139 dp101 0 0.032886p
Rj140 dmx104 dm102 1m
Lv142 dp101 u141 1.358n
Cv142 u141 0 0.4885p
Rt144 u141 tm143 0.00243101
Lt144 tm143 rp_b 0.326667n
Ct144 rp_b 0 0.0605706p
Lv146 dm102 u145 1.358n
Cv146 u145 0 0.4885p
Rt148 u145 tm147 0.00283083
Lt148 tm147 rm_b 0.380392n
Ct148 rm_b 0 0.0705322p
Cu10p conp 0 0.7p
Cu10m conm 0 0.7p
Rst152 conp stm150 0.00551383
Lst152 stm150 st151 0.74092n
Cst152 st151 0 0.137381p
Rst155 st151 stm153 0.00551383
Lst155 stm153 st154 0.74092n
Cst155 st154 0 0.137381p
Rst157 st154 stm156 0.00551383
Lst157 stm156 st149 0.74092n
Cst157 st149 0 0.137381p
Cst158 st149 0 0.3p
Rst162 conm stm160 0.00548216
Lst162 stm160 st161 0.736664n
Cst162 st161 0 0.136592p
Rst165 st161 stm163 0.00548216
Lst165 stm163 st164 0.736664n
Cst165 st164 0 0.136592p
Rst167 st164 stm166 0.00548216
Lst167 stm166 st159 0.736664n
Cst167 st159 0 0.136592p
Cst168 st159 0 0.3p
Cconp conp 0 0.6p
Cconm conm 0 0.6p
Clp conp 0 50p
Clm conm 0 50p
Rlp conp 0 15k
Rlm conm 0 15k
.options method=gear reltol=2e-3
.tran 0.1n 5333.3n 0 0.2n
.control
set wr_singlescale
set wr_vecnames
set numdgt=7
run

wrdata /out/usb_00_device_tx_4ns.txt v(conp) v(conm) v(conp) v(conm)
.endc
.end
