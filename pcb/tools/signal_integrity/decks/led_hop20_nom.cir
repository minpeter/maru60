* led_hop20_nom: SK6805 DOUT (assumed 100 ohm, 10 ns) -> 100 ohm in series -> routed hop -> DIN 5 pF
Vsrc src 0 PWL(0.0000n 0 100.0000n 0 110.0000n 4 400.0000n 4 410.0000n 0 1300.0000n 0 1310.0000n 4 2200.0000n 4 2210.0000n 0 2500.0000n 0 2510.0000n 4 2800.0000n 4 2810.0000n 0 3700.0000n 0 3710.0000n 4 4600.0000n 4 4610.0000n 0)
Rdrv src dout 100.0
Cdout dout 0 2p
Rt3 dout tm2 0.00218393
Lt3 tm2 p1 0.293465n
Ct3 p1 0 0.0544143p
Lv5 p1 v4 1.358n
Cv5 v4 0 0.4885p
Rt7 v4 tm6 0.00421624
Lt7 tm6 rs_a 0.566557n
Ct7 rs_a 0 0.105051p
Rser rs_a rs_b 100
Cser rs_b 0 0.1p
Rt11 rs_b tm9 0.00628693
Lt11 tm9 t10 0.844805n
Ct11 t10 0 0.156644p
Rt14 t10 tm12 0.00628693
Lt14 tm12 t13 0.844805n
Ct14 t13 0 0.156644p
Rt17 t13 tm15 0.00628693
Lt17 tm15 t16 0.844805n
Ct17 t16 0 0.156644p
Rt20 t16 tm18 0.00628693
Lt20 tm18 t19 0.844805n
Ct20 t19 0 0.156644p
Rt23 t19 tm21 0.00628693
Lt23 tm21 t22 0.844805n
Ct23 t22 0 0.156644p
Rt26 t22 tm24 0.00628693
Lt26 tm24 t25 0.844805n
Ct26 t25 0 0.156644p
Rt29 t25 tm27 0.00628693
Lt29 tm27 t28 0.844805n
Ct29 t28 0 0.156644p
Rt32 t28 tm30 0.00628693
Lt32 tm30 t31 0.844805n
Ct32 t31 0 0.156644p
Rt34 t31 tm33 0.00628693
Lt34 tm33 p8 0.844805n
Ct34 p8 0 0.156644p
Lv36 p8 v35 1.358n
Cv36 v35 0 0.4885p
Rt40 v35 tm38 0.00566744
Lt40 tm38 t39 0.761562n
Ct40 t39 0 0.141209p
Rt43 t39 tm41 0.00566744
Lt43 tm41 t42 0.761562n
Ct43 t42 0 0.141209p
Rt46 t42 tm44 0.00566744
Lt46 tm44 t45 0.761562n
Ct46 t45 0 0.141209p
Rt49 t45 tm47 0.00566744
Lt49 tm47 t48 0.761562n
Ct49 t48 0 0.141209p
Rt52 t48 tm50 0.00566744
Lt52 tm50 t51 0.761562n
Ct52 t51 0 0.141209p
Rt55 t51 tm53 0.00566744
Lt55 tm53 t54 0.761562n
Ct55 t54 0 0.141209p
Rt57 t54 tm56 0.00566744
Lt57 tm56 p37 0.761562n
Ct57 p37 0 0.141209p
Rs60 p37 sm59 0.000781371
Ls60 sm59 stubend58 0.124179n
Cs60 stubend58 0 0.0295819p
Cs61 stubend58 0 0.15p
Rt63 p37 tm62 1.63668e-05
Lt63 tm62 din 0.00219928n
Ct63 din 0 0.000407791p
Cin din 0 5p
.tran 0.1n 5000n 0 0.2n
.control
set wr_singlescale
set wr_vecnames
set numdgt=7
run

wrdata /out/led_hop20_nom.txt v(dout) v(din)
.endc
.end
