* led_hop11_weak: SK6805 DOUT (assumed 500 ohm, 30 ns) -> 100 ohm in series -> routed hop -> DIN 5 pF
Vsrc src 0 PWL(0.0000n 0 100.0000n 0 130.0000n 4 400.0000n 4 430.0000n 0 1300.0000n 0 1330.0000n 4 2200.0000n 4 2230.0000n 0 2500.0000n 0 2530.0000n 4 2800.0000n 4 2830.0000n 0 3700.0000n 0 3730.0000n 4 4600.0000n 4 4630.0000n 0)
Rdrv src dout 500.0
Cdout dout 0 2p
Rt3 dout tm2 0.00196571
Lt3 tm2 p1 0.264143n
Ct3 p1 0 0.0489773p
Lv5 p1 v4 1.358n
Cv5 v4 0 0.4885p
Rt7 v4 tm6 0.00343518
Lt7 tm6 rs_a 0.461601n
Ct7 rs_a 0 0.0855901p
Rser rs_a rs_b 100
Cser rs_b 0 0.1p
Rt11 rs_b tm9 0.00653192
Lt11 tm9 t10 0.877726n
Ct11 t10 0 0.162748p
Rt14 t10 tm12 0.00653192
Lt14 tm12 t13 0.877726n
Ct14 t13 0 0.162748p
Rt17 t13 tm15 0.00653192
Lt17 tm15 t16 0.877726n
Ct17 t16 0 0.162748p
Rt20 t16 tm18 0.00653192
Lt20 tm18 t19 0.877726n
Ct20 t19 0 0.162748p
Rt23 t19 tm21 0.00653192
Lt23 tm21 t22 0.877726n
Ct23 t22 0 0.162748p
Rt26 t22 tm24 0.00653192
Lt26 tm24 t25 0.877726n
Ct26 t25 0 0.162748p
Rt29 t25 tm27 0.00653192
Lt29 tm27 t28 0.877726n
Ct29 t28 0 0.162748p
Rt32 t28 tm30 0.00653192
Lt32 tm30 t31 0.877726n
Ct32 t31 0 0.162748p
Rt35 t31 tm33 0.00653192
Lt35 tm33 t34 0.877726n
Ct35 t34 0 0.162748p
Rt38 t34 tm36 0.00653192
Lt38 tm36 t37 0.877726n
Ct38 t37 0 0.162748p
Rt41 t37 tm39 0.00653192
Lt41 tm39 t40 0.877726n
Ct41 t40 0 0.162748p
Rt44 t40 tm42 0.00653192
Lt44 tm42 t43 0.877726n
Ct44 t43 0 0.162748p
Rt47 t43 tm45 0.00653192
Lt47 tm45 t46 0.877726n
Ct47 t46 0 0.162748p
Rt50 t46 tm48 0.00653192
Lt50 tm48 t49 0.877726n
Ct50 t49 0 0.162748p
Rt53 t49 tm51 0.00653192
Lt53 tm51 t52 0.877726n
Ct53 t52 0 0.162748p
Rt56 t52 tm54 0.00653192
Lt56 tm54 t55 0.877726n
Ct56 t55 0 0.162748p
Rt59 t55 tm57 0.00653192
Lt59 tm57 t58 0.877726n
Ct59 t58 0 0.162748p
Rt62 t58 tm60 0.00653192
Lt62 tm60 t61 0.877726n
Ct62 t61 0 0.162748p
Rt65 t61 tm63 0.00653192
Lt65 tm63 t64 0.877726n
Ct65 t64 0 0.162748p
Rt67 t64 tm66 0.00653192
Lt67 tm66 p8 0.877726n
Ct67 p8 0 0.162748p
Lv69 p8 v68 1.358n
Cv69 v68 0 0.4885p
Rt71 v68 tm70 0.00170422
Lt71 tm70 din 0.270843n
Ct71 din 0 0.0645199p
Cin din 0 5p
.tran 0.1n 5000n 0 0.2n
.control
set wr_singlescale
set wr_vecnames
set numdgt=7
run

wrdata /out/led_hop11_weak.txt v(dout) v(din)
.endc
.end
