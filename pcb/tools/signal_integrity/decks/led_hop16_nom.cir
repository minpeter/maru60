* led_hop16_nom: SK6805 DOUT (assumed 100 ohm, 10 ns) -> 100 ohm in series -> routed hop -> DIN 5 pF
Vsrc src 0 PWL(0.0000n 0 100.0000n 0 110.0000n 4 400.0000n 4 410.0000n 0 1300.0000n 0 1310.0000n 4 2200.0000n 4 2210.0000n 0 2500.0000n 0 2510.0000n 4 2800.0000n 4 2810.0000n 0 3700.0000n 0 3710.0000n 4 4600.0000n 4 4610.0000n 0)
Rdrv src dout 100.0
Cdout dout 0 2p
Rt4 dout tm2 0.00380038
Lt4 tm2 t3 0.690502n
Ct4 t3 0 0.198894p
Rt7 t3 tm5 0.00380038
Lt7 tm5 t6 0.690502n
Ct7 t6 0 0.198894p
Rt9 t6 tm8 0.00380038
Lt9 tm8 p1 0.690502n
Ct9 p1 0 0.198894p
Rs13 p1 sm11 0.00454621
Ls13 sm11 s12 0.722505n
Cs13 s12 0 0.172114p
Rs16 s12 sm14 0.00454621
Ls16 sm14 s15 0.722505n
Cs16 s15 0 0.172114p
Rs19 s15 sm17 0.00454621
Ls19 sm17 s18 0.722505n
Cs19 s18 0 0.172114p
Rs22 s18 sm20 0.00454621
Ls22 sm20 s21 0.722505n
Cs22 s21 0 0.172114p
Rs24 s21 sm23 0.00454621
Ls24 sm23 stubend10 0.722505n
Cs24 stubend10 0 0.172114p
Cs25 stubend10 0 0.4885p
Cs26 stubend10 0 0.15p
Rj28 p1 p27 1m
Rt30 p27 tm29 0.00155423
Lt30 tm29 rs_a 0.247006n
Ct30 rs_a 0 0.0588414p
Rser rs_a rs_b 100
Cser rs_b 0 0.1p
Rt33 rs_b tm32 0.00315228
Lt33 tm32 p31 0.500976n
Ct33 p31 0 0.119342p
Lv35 p31 v34 1.358n
Cv35 v34 0 0.4885p
Rt38 v34 tm36 0.00466209
Lt38 tm36 t37 0.740922n
Ct38 t37 0 0.176502p
Rt41 t37 tm39 0.00466209
Lt41 tm39 t40 0.740922n
Ct41 t40 0 0.176502p
Rt44 t40 tm42 0.00466209
Lt44 tm42 t43 0.740922n
Ct44 t43 0 0.176502p
Rt47 t43 tm45 0.00466209
Lt47 tm45 t46 0.740922n
Ct47 t46 0 0.176502p
Rt50 t46 tm48 0.00466209
Lt50 tm48 t49 0.740922n
Ct50 t49 0 0.176502p
Rt53 t49 tm51 0.00466209
Lt53 tm51 t52 0.740922n
Ct53 t52 0 0.176502p
Rt56 t52 tm54 0.00466209
Lt56 tm54 t55 0.740922n
Ct56 t55 0 0.176502p
Rt59 t55 tm57 0.00466209
Lt59 tm57 t58 0.740922n
Ct59 t58 0 0.176502p
Rt62 t58 tm60 0.00466209
Lt62 tm60 t61 0.740922n
Ct62 t61 0 0.176502p
Rt65 t61 tm63 0.00466209
Lt65 tm63 t64 0.740922n
Ct65 t64 0 0.176502p
Rt68 t64 tm66 0.00466209
Lt68 tm66 t67 0.740922n
Ct68 t67 0 0.176502p
Rt71 t67 tm69 0.00466209
Lt71 tm69 t70 0.740922n
Ct71 t70 0 0.176502p
Rt73 t70 tm72 0.00466209
Lt73 tm72 din 0.740922n
Ct73 din 0 0.176502p
Cin din 0 5p
.tran 0.1n 5000n 0 0.2n
.control
set wr_singlescale
set wr_vecnames
set numdgt=7
run

wrdata /out/led_hop16_nom.txt v(dout) v(din)
.endc
.end
