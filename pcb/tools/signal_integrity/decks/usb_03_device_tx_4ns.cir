* USB full speed, device_tx, source ramp 4 ns, cable 1 m
Vdp sp 0 PWL(0.0000n 3.3 331.3333n 3.3 335.3333n 0 414.6667n 0 418.6667n 3.3 498.0000n 3.3 502.0000n 0 581.3333n 0 585.3333n 3.3 664.6667n 3.3 668.6667n 0 748.0000n 0 752.0000n 3.3 831.3333n 3.3 835.3333n 0 998.0000n 0 1002.0000n 3.3 1081.3333n 3.3 1085.3333n 0 1331.3333n 0 1335.3333n 3.3 1498.0000n 3.3 1502.0000n 0 1581.3333n 0 1585.3333n 3.3 2164.6667n 3.3 2168.6667n 0 2248.0000n 0 2252.0000n 3.3 2331.3333n 3.3 2335.3333n 0 2914.6667n 0 2918.6667n 3.3 2998.0000n 3.3 3002.0000n 0 3081.3333n 0 3085.3333n 3.3 3248.0000n 3.3 3252.0000n 0 3414.6667n 0 3418.6667n 3.3 3664.6667n 3.3 3668.6667n 0 3998.0000n 0 4002.0000n 3.3 4081.3333n 3.3 4085.3333n 0 4164.6667n 0 4168.6667n 3.3 4581.3333n 3.3 4585.3333n 0 4664.6667n 0 4668.6667n 3.3 4748.0000n 3.3 4752.0000n 0 4914.6667n 0 4918.6667n 3.3 5081.3333n 3.3 5085.3333n 0 5164.6667n 0 5168.6667n 3.3)
Vdm sm 0 PWL(0.0000n 0 331.3333n 0 335.3333n 3.3 414.6667n 3.3 418.6667n 0 498.0000n 0 502.0000n 3.3 581.3333n 3.3 585.3333n 0 664.6667n 0 668.6667n 3.3 748.0000n 3.3 752.0000n 0 831.3333n 0 835.3333n 3.3 998.0000n 3.3 1002.0000n 0 1081.3333n 0 1085.3333n 3.3 1331.3333n 3.3 1335.3333n 0 1498.0000n 0 1502.0000n 3.3 1581.3333n 3.3 1585.3333n 0 2164.6667n 0 2168.6667n 3.3 2248.0000n 3.3 2252.0000n 0 2331.3333n 0 2335.3333n 3.3 2914.6667n 3.3 2918.6667n 0 2998.0000n 0 3002.0000n 3.3 3081.3333n 3.3 3085.3333n 0 3248.0000n 0 3252.0000n 3.3 3414.6667n 3.3 3418.6667n 0 3664.6667n 0 3668.6667n 3.3 3998.0000n 3.3 4002.0000n 0 4081.3333n 0 4085.3333n 3.3 4164.6667n 3.3 4168.6667n 0 4581.3333n 0 4585.3333n 3.3 4664.6667n 3.3 4668.6667n 0 4748.0000n 0 4752.0000n 3.3 4914.6667n 3.3 4918.6667n 0 5081.3333n 0 5085.3333n 3.3 5164.6667n 3.3 5168.6667n 0)
Rphyp sp pinp 9
Rphym sm pinm 9
Cpinp pinp 0 5p
Cpinm pinm 0 5p
Vpu vpu 0 3.3
Rpu vpu pinp 1.5k
Rt3 pinp tm1 0.00448183
Lt3 tm1 t2 0.602245n
Ct3 t2 0 0.111668p
Rt6 t2 tm4 0.00448183
Lt6 tm4 t5 0.602245n
Ct6 t5 0 0.111668p
Rt8 t5 tm7 0.00448183
Lt8 tm7 rp_a 0.602245n
Ct8 rp_a 0 0.111668p
Rt11 pinm tm9 0.00625752
Lt11 tm9 t10 0.840854n
Ct11 t10 0 0.155911p
Rt13 t10 tm12 0.00625752
Lt13 tm12 rm_a 0.840854n
Ct13 rm_a 0 0.155911p
R102 rp_a rp_b 27
R103 rm_a rm_b 27
Rt18 conp tm17 0.0030141
Lt18 tm17 u16 0.405019n
Ct18 u16 0 0.0750985p
Lv20 u16 u19 1.358n
Cv20 u19 0 0.4885p
Rt23 u19 tm21 0.0058536
Lt23 tm21 t22 0.786577n
Ct23 t22 0 0.145847p
Rt26 t22 tm24 0.0058536
Lt26 tm24 t25 0.786577n
Ct26 t25 0 0.145847p
Rt29 t25 tm27 0.0058536
Lt29 tm27 t28 0.786577n
Ct29 t28 0 0.145847p
Rt31 t28 tm30 0.0058536
Lt31 tm30 dp14 0.786577n
Ct31 dp14 0 0.145847p
Rt35 conm tm33 0.00596219
Lt35 tm33 t34 0.801168n
Ct35 t34 0 0.148553p
Rt38 t34 tm36 0.00596219
Lt38 tm36 t37 0.801168n
Ct38 t37 0 0.148553p
Rt40 t37 tm39 0.00596219
Lt40 tm39 u32 0.801168n
Ct40 u32 0 0.148553p
Lv42 u32 u41 1.358n
Cv42 u41 0 0.4885p
Rt45 u41 tm43 0.00520452
Lt45 tm43 t44 0.699357n
Ct45 t44 0 0.129675p
Rt48 t44 tm46 0.00520452
Lt48 tm46 t47 0.699357n
Ct48 t47 0 0.129675p
Rt50 t47 tm49 0.00520452
Lt50 tm49 dm15 0.699357n
Ct50 dm15 0 0.129675p
Rp1a57 dp14 p1ra58 0.00558854
Rp1b57 dm15 p1rb59 0.00558854
Lp1a57 p1ra58 p1a55 1.00306n
Lp1b57 p1rb59 p1b56 1.00306n
Kp157 Lp1a57 Lp1b57 0.22195
Cp1a57 p1a55 0 0.25838p
Cp1b57 p1b56 0 0.25838p
Cp1m57 p1a55 p1b56 0.0433125p
Rp1a62 p1a55 p1ra63 0.00558854
Rp1b62 p1b56 p1rb64 0.00558854
Lp1a62 p1ra63 p1a60 1.00306n
Lp1b62 p1rb64 p1b61 1.00306n
Kp162 Lp1a62 Lp1b62 0.22195
Cp1a62 p1a60 0 0.25838p
Cp1b62 p1b61 0 0.25838p
Cp1m62 p1a60 p1b61 0.0433125p
Rp1a67 p1a60 p1ra68 0.00558854
Rp1b67 p1b61 p1rb69 0.00558854
Lp1a67 p1ra68 p1a65 1.00306n
Lp1b67 p1rb69 p1b66 1.00306n
Kp167 Lp1a67 Lp1b67 0.22195
Cp1a67 p1a65 0 0.25838p
Cp1b67 p1b66 0 0.25838p
Cp1m67 p1a65 p1b66 0.0433125p
Rp1a72 p1a65 p1ra73 0.00558854
Rp1b72 p1b66 p1rb74 0.00558854
Lp1a72 p1ra73 p1a70 1.00306n
Lp1b72 p1rb74 p1b71 1.00306n
Kp172 Lp1a72 Lp1b72 0.22195
Cp1a72 p1a70 0 0.25838p
Cp1b72 p1b71 0 0.25838p
Cp1m72 p1a70 p1b71 0.0433125p
Rp1a77 p1a70 p1ra78 0.00558854
Rp1b77 p1b71 p1rb79 0.00558854
Lp1a77 p1ra78 p1a75 1.00306n
Lp1b77 p1rb79 p1b76 1.00306n
Kp177 Lp1a77 Lp1b77 0.22195
Cp1a77 p1a75 0 0.25838p
Cp1b77 p1b76 0 0.25838p
Cp1m77 p1a75 p1b76 0.0433125p
Rp1a82 p1a75 p1ra83 0.00558854
Rp1b82 p1b76 p1rb84 0.00558854
Lp1a82 p1ra83 p1a80 1.00306n
Lp1b82 p1rb84 p1b81 1.00306n
Kp182 Lp1a82 Lp1b82 0.22195
Cp1a82 p1a80 0 0.25838p
Cp1b82 p1b81 0 0.25838p
Cp1m82 p1a80 p1b81 0.0433125p
Rp1a87 p1a80 p1ra88 0.00558854
Rp1b87 p1b81 p1rb89 0.00558854
Lp1a87 p1ra88 p1a85 1.00306n
Lp1b87 p1rb89 p1b86 1.00306n
Kp187 Lp1a87 Lp1b87 0.22195
Cp1a87 p1a85 0 0.25838p
Cp1b87 p1b86 0 0.25838p
Cp1m87 p1a85 p1b86 0.0433125p
Rp1a92 p1a85 p1ra93 0.00558854
Rp1b92 p1b86 p1rb94 0.00558854
Lp1a92 p1ra93 p1a90 1.00306n
Lp1b92 p1rb94 p1b91 1.00306n
Kp192 Lp1a92 Lp1b92 0.22195
Cp1a92 p1a90 0 0.25838p
Cp1b92 p1b91 0 0.25838p
Cp1m92 p1a90 p1b91 0.0433125p
Rp1a97 p1a90 p1ra98 0.00558854
Rp1b97 p1b91 p1rb99 0.00558854
Lp1a97 p1ra98 p1a95 1.00306n
Lp1b97 p1rb99 p1b96 1.00306n
Kp197 Lp1a97 Lp1b97 0.22195
Cp1a97 p1a95 0 0.25838p
Cp1b97 p1b96 0 0.25838p
Cp1m97 p1a95 p1b96 0.0433125p
Rp1a102 p1a95 p1ra103 0.00558854
Rp1b102 p1b96 p1rb104 0.00558854
Lp1a102 p1ra103 p1a100 1.00306n
Lp1b102 p1rb104 p1b101 1.00306n
Kp1102 Lp1a102 Lp1b102 0.22195
Cp1a102 p1a100 0 0.25838p
Cp1b102 p1b101 0 0.25838p
Cp1m102 p1a100 p1b101 0.0433125p
Rp1a107 p1a100 p1ra108 0.00558854
Rp1b107 p1b101 p1rb109 0.00558854
Lp1a107 p1ra108 p1a105 1.00306n
Lp1b107 p1rb109 p1b106 1.00306n
Kp1107 Lp1a107 Lp1b107 0.22195
Cp1a107 p1a105 0 0.25838p
Cp1b107 p1b106 0 0.25838p
Cp1m107 p1a105 p1b106 0.0433125p
Rp1a112 p1a105 p1ra113 0.00558854
Rp1b112 p1b106 p1rb114 0.00558854
Lp1a112 p1ra113 p1a110 1.00306n
Lp1b112 p1rb114 p1b111 1.00306n
Kp1112 Lp1a112 Lp1b112 0.22195
Cp1a112 p1a110 0 0.25838p
Cp1b112 p1b111 0 0.25838p
Cp1m112 p1a110 p1b111 0.0433125p
Rp1a117 p1a110 p1ra118 0.00558854
Rp1b117 p1b111 p1rb119 0.00558854
Lp1a117 p1ra118 p1a115 1.00306n
Lp1b117 p1rb119 p1b116 1.00306n
Kp1117 Lp1a117 Lp1b117 0.22195
Cp1a117 p1a115 0 0.25838p
Cp1b117 p1b116 0 0.25838p
Cp1m117 p1a115 p1b116 0.0433125p
Rp1a120 p1a115 p1ra121 0.00558854
Rp1b120 p1b116 p1rb122 0.00558854
Lp1a120 p1ra121 dpx53 1.00306n
Lp1b120 p1rb122 dmx54 1.00306n
Kp1120 Lp1a120 Lp1b120 0.22195
Cp1a120 dpx53 0 0.25838p
Cp1b120 dmx54 0 0.25838p
Cp1m120 dpx53 dmx54 0.0433125p
Rj123 dpx53 dp51 1m
Rt125 dmx54 tm124 0.000157137
Lt125 tm124 dm52 0.0285507n
Ct125 dm52 0 0.00822381p
Rt130 dp51 tm129 0.00318077
Lt130 tm129 u128 0.427416n
Ct130 u128 0 0.0792514p
Lv132 u128 u131 1.358n
Cv132 u131 0 0.4885p
Rt134 u131 tm133 0.00144787
Lt134 tm133 dp126 0.194558n
Ct134 dp126 0 0.0360749p
Rt137 dm52 tm136 0.00243898
Lt137 tm136 u135 0.327737n
Ct137 u135 0 0.060769p
Lv139 u135 u138 1.358n
Cv139 u138 0 0.4885p
Rt141 u138 tm140 0.00230009
Lt141 tm140 dm127 0.309075n
Ct141 dm127 0 0.0573087p
Rp3a148 dp126 p3ra149 0.00576745
Rp3b148 dm127 p3rb150 0.00576745
Lp3a148 p3ra149 p3a146 1.03517n
Lp3b148 p3rb150 p3b147 1.03517n
Kp3148 Lp3a148 Lp3b148 0.22195
Cp3a148 p3a146 0 0.266651p
Cp3b148 p3b147 0 0.266651p
Cp3m148 p3a146 p3b147 0.0446991p
Rp3a153 p3a146 p3ra154 0.00576745
Rp3b153 p3b147 p3rb155 0.00576745
Lp3a153 p3ra154 p3a151 1.03517n
Lp3b153 p3rb155 p3b152 1.03517n
Kp3153 Lp3a153 Lp3b153 0.22195
Cp3a153 p3a151 0 0.266651p
Cp3b153 p3b152 0 0.266651p
Cp3m153 p3a151 p3b152 0.0446991p
Rp3a158 p3a151 p3ra159 0.00576745
Rp3b158 p3b152 p3rb160 0.00576745
Lp3a158 p3ra159 p3a156 1.03517n
Lp3b158 p3rb160 p3b157 1.03517n
Kp3158 Lp3a158 Lp3b158 0.22195
Cp3a158 p3a156 0 0.266651p
Cp3b158 p3b157 0 0.266651p
Cp3m158 p3a156 p3b157 0.0446991p
Rp3a163 p3a156 p3ra164 0.00576745
Rp3b163 p3b157 p3rb165 0.00576745
Lp3a163 p3ra164 p3a161 1.03517n
Lp3b163 p3rb165 p3b162 1.03517n
Kp3163 Lp3a163 Lp3b163 0.22195
Cp3a163 p3a161 0 0.266651p
Cp3b163 p3b162 0 0.266651p
Cp3m163 p3a161 p3b162 0.0446991p
Rp3a168 p3a161 p3ra169 0.00576745
Rp3b168 p3b162 p3rb170 0.00576745
Lp3a168 p3ra169 p3a166 1.03517n
Lp3b168 p3rb170 p3b167 1.03517n
Kp3168 Lp3a168 Lp3b168 0.22195
Cp3a168 p3a166 0 0.266651p
Cp3b168 p3b167 0 0.266651p
Cp3m168 p3a166 p3b167 0.0446991p
Rp3a173 p3a166 p3ra174 0.00576745
Rp3b173 p3b167 p3rb175 0.00576745
Lp3a173 p3ra174 p3a171 1.03517n
Lp3b173 p3rb175 p3b172 1.03517n
Kp3173 Lp3a173 Lp3b173 0.22195
Cp3a173 p3a171 0 0.266651p
Cp3b173 p3b172 0 0.266651p
Cp3m173 p3a171 p3b172 0.0446991p
Rp3a178 p3a171 p3ra179 0.00576745
Rp3b178 p3b172 p3rb180 0.00576745
Lp3a178 p3ra179 p3a176 1.03517n
Lp3b178 p3rb180 p3b177 1.03517n
Kp3178 Lp3a178 Lp3b178 0.22195
Cp3a178 p3a176 0 0.266651p
Cp3b178 p3b177 0 0.266651p
Cp3m178 p3a176 p3b177 0.0446991p
Rp3a183 p3a176 p3ra184 0.00576745
Rp3b183 p3b177 p3rb185 0.00576745
Lp3a183 p3ra184 p3a181 1.03517n
Lp3b183 p3rb185 p3b182 1.03517n
Kp3183 Lp3a183 Lp3b183 0.22195
Cp3a183 p3a181 0 0.266651p
Cp3b183 p3b182 0 0.266651p
Cp3m183 p3a181 p3b182 0.0446991p
Rp3a188 p3a181 p3ra189 0.00576745
Rp3b188 p3b182 p3rb190 0.00576745
Lp3a188 p3ra189 p3a186 1.03517n
Lp3b188 p3rb190 p3b187 1.03517n
Kp3188 Lp3a188 Lp3b188 0.22195
Cp3a188 p3a186 0 0.266651p
Cp3b188 p3b187 0 0.266651p
Cp3m188 p3a186 p3b187 0.0446991p
Rp3a193 p3a186 p3ra194 0.00576745
Rp3b193 p3b187 p3rb195 0.00576745
Lp3a193 p3ra194 p3a191 1.03517n
Lp3b193 p3rb195 p3b192 1.03517n
Kp3193 Lp3a193 Lp3b193 0.22195
Cp3a193 p3a191 0 0.266651p
Cp3b193 p3b192 0 0.266651p
Cp3m193 p3a191 p3b192 0.0446991p
Rp3a198 p3a191 p3ra199 0.00576745
Rp3b198 p3b192 p3rb200 0.00576745
Lp3a198 p3ra199 p3a196 1.03517n
Lp3b198 p3rb200 p3b197 1.03517n
Kp3198 Lp3a198 Lp3b198 0.22195
Cp3a198 p3a196 0 0.266651p
Cp3b198 p3b197 0 0.266651p
Cp3m198 p3a196 p3b197 0.0446991p
Rp3a203 p3a196 p3ra204 0.00576745
Rp3b203 p3b197 p3rb205 0.00576745
Lp3a203 p3ra204 p3a201 1.03517n
Lp3b203 p3rb205 p3b202 1.03517n
Kp3203 Lp3a203 Lp3b203 0.22195
Cp3a203 p3a201 0 0.266651p
Cp3b203 p3b202 0 0.266651p
Cp3m203 p3a201 p3b202 0.0446991p
Rp3a208 p3a201 p3ra209 0.00576745
Rp3b208 p3b202 p3rb210 0.00576745
Lp3a208 p3ra209 p3a206 1.03517n
Lp3b208 p3rb210 p3b207 1.03517n
Kp3208 Lp3a208 Lp3b208 0.22195
Cp3a208 p3a206 0 0.266651p
Cp3b208 p3b207 0 0.266651p
Cp3m208 p3a206 p3b207 0.0446991p
Rp3a213 p3a206 p3ra214 0.00576745
Rp3b213 p3b207 p3rb215 0.00576745
Lp3a213 p3ra214 p3a211 1.03517n
Lp3b213 p3rb215 p3b212 1.03517n
Kp3213 Lp3a213 Lp3b213 0.22195
Cp3a213 p3a211 0 0.266651p
Cp3b213 p3b212 0 0.266651p
Cp3m213 p3a211 p3b212 0.0446991p
Rp3a218 p3a211 p3ra219 0.00576745
Rp3b218 p3b212 p3rb220 0.00576745
Lp3a218 p3ra219 p3a216 1.03517n
Lp3b218 p3rb220 p3b217 1.03517n
Kp3218 Lp3a218 Lp3b218 0.22195
Cp3a218 p3a216 0 0.266651p
Cp3b218 p3b217 0 0.266651p
Cp3m218 p3a216 p3b217 0.0446991p
Rp3a223 p3a216 p3ra224 0.00576745
Rp3b223 p3b217 p3rb225 0.00576745
Lp3a223 p3ra224 p3a221 1.03517n
Lp3b223 p3rb225 p3b222 1.03517n
Kp3223 Lp3a223 Lp3b223 0.22195
Cp3a223 p3a221 0 0.266651p
Cp3b223 p3b222 0 0.266651p
Cp3m223 p3a221 p3b222 0.0446991p
Rp3a228 p3a221 p3ra229 0.00576745
Rp3b228 p3b222 p3rb230 0.00576745
Lp3a228 p3ra229 p3a226 1.03517n
Lp3b228 p3rb230 p3b227 1.03517n
Kp3228 Lp3a228 Lp3b228 0.22195
Cp3a228 p3a226 0 0.266651p
Cp3b228 p3b227 0 0.266651p
Cp3m228 p3a226 p3b227 0.0446991p
Rp3a233 p3a226 p3ra234 0.00576745
Rp3b233 p3b227 p3rb235 0.00576745
Lp3a233 p3ra234 p3a231 1.03517n
Lp3b233 p3rb235 p3b232 1.03517n
Kp3233 Lp3a233 Lp3b233 0.22195
Cp3a233 p3a231 0 0.266651p
Cp3b233 p3b232 0 0.266651p
Cp3m233 p3a231 p3b232 0.0446991p
Rp3a238 p3a231 p3ra239 0.00576745
Rp3b238 p3b232 p3rb240 0.00576745
Lp3a238 p3ra239 p3a236 1.03517n
Lp3b238 p3rb240 p3b237 1.03517n
Kp3238 Lp3a238 Lp3b238 0.22195
Cp3a238 p3a236 0 0.266651p
Cp3b238 p3b237 0 0.266651p
Cp3m238 p3a236 p3b237 0.0446991p
Rp3a243 p3a236 p3ra244 0.00576745
Rp3b243 p3b237 p3rb245 0.00576745
Lp3a243 p3ra244 p3a241 1.03517n
Lp3b243 p3rb245 p3b242 1.03517n
Kp3243 Lp3a243 Lp3b243 0.22195
Cp3a243 p3a241 0 0.266651p
Cp3b243 p3b242 0 0.266651p
Cp3m243 p3a241 p3b242 0.0446991p
Rp3a248 p3a241 p3ra249 0.00576745
Rp3b248 p3b242 p3rb250 0.00576745
Lp3a248 p3ra249 p3a246 1.03517n
Lp3b248 p3rb250 p3b247 1.03517n
Kp3248 Lp3a248 Lp3b248 0.22195
Cp3a248 p3a246 0 0.266651p
Cp3b248 p3b247 0 0.266651p
Cp3m248 p3a246 p3b247 0.0446991p
Rp3a253 p3a246 p3ra254 0.00576745
Rp3b253 p3b247 p3rb255 0.00576745
Lp3a253 p3ra254 p3a251 1.03517n
Lp3b253 p3rb255 p3b252 1.03517n
Kp3253 Lp3a253 Lp3b253 0.22195
Cp3a253 p3a251 0 0.266651p
Cp3b253 p3b252 0 0.266651p
Cp3m253 p3a251 p3b252 0.0446991p
Rp3a258 p3a251 p3ra259 0.00576745
Rp3b258 p3b252 p3rb260 0.00576745
Lp3a258 p3ra259 p3a256 1.03517n
Lp3b258 p3rb260 p3b257 1.03517n
Kp3258 Lp3a258 Lp3b258 0.22195
Cp3a258 p3a256 0 0.266651p
Cp3b258 p3b257 0 0.266651p
Cp3m258 p3a256 p3b257 0.0446991p
Rp3a263 p3a256 p3ra264 0.00576745
Rp3b263 p3b257 p3rb265 0.00576745
Lp3a263 p3ra264 p3a261 1.03517n
Lp3b263 p3rb265 p3b262 1.03517n
Kp3263 Lp3a263 Lp3b263 0.22195
Cp3a263 p3a261 0 0.266651p
Cp3b263 p3b262 0 0.266651p
Cp3m263 p3a261 p3b262 0.0446991p
Rp3a268 p3a261 p3ra269 0.00576745
Rp3b268 p3b262 p3rb270 0.00576745
Lp3a268 p3ra269 p3a266 1.03517n
Lp3b268 p3rb270 p3b267 1.03517n
Kp3268 Lp3a268 Lp3b268 0.22195
Cp3a268 p3a266 0 0.266651p
Cp3b268 p3b267 0 0.266651p
Cp3m268 p3a266 p3b267 0.0446991p
Rp3a273 p3a266 p3ra274 0.00576745
Rp3b273 p3b267 p3rb275 0.00576745
Lp3a273 p3ra274 p3a271 1.03517n
Lp3b273 p3rb275 p3b272 1.03517n
Kp3273 Lp3a273 Lp3b273 0.22195
Cp3a273 p3a271 0 0.266651p
Cp3b273 p3b272 0 0.266651p
Cp3m273 p3a271 p3b272 0.0446991p
Rp3a278 p3a271 p3ra279 0.00576745
Rp3b278 p3b272 p3rb280 0.00576745
Lp3a278 p3ra279 p3a276 1.03517n
Lp3b278 p3rb280 p3b277 1.03517n
Kp3278 Lp3a278 Lp3b278 0.22195
Cp3a278 p3a276 0 0.266651p
Cp3b278 p3b277 0 0.266651p
Cp3m278 p3a276 p3b277 0.0446991p
Rp3a281 p3a276 p3ra282 0.00576745
Rp3b281 p3b277 p3rb283 0.00576745
Lp3a281 p3ra282 dpx144 1.03517n
Lp3b281 p3rb283 dmx145 1.03517n
Kp3281 Lp3a281 Lp3b281 0.22195
Cp3a281 dpx144 0 0.266651p
Cp3b281 dmx145 0 0.266651p
Cp3m281 dpx144 dmx145 0.0446991p
Rj284 dpx144 dp142 1m
Rt286 dmx145 tm285 0.000757596
Lt286 tm285 dm143 0.13765n
Ct286 dm143 0 0.039649p
Rt291 dp142 tm290 0.00643789
Lt291 tm290 u289 0.86509n
Ct291 u289 0 0.160405p
Lv293 u289 u292 1.358n
Cv293 u292 0 0.4885p
Rt296 u292 tm294 0.0033742
Lt296 tm294 t295 0.453408n
Ct296 t295 0 0.0840709p
Rt298 t295 tm297 0.0033742
Lt298 tm297 dp287 0.453408n
Ct298 dp287 0 0.0840709p
Rt301 dm143 tm300 0.00628268
Lt301 tm300 u299 0.844235n
Ct301 u299 0 0.156538p
Lv303 u299 u302 1.358n
Cv303 u302 0 0.4885p
Rt305 u302 tm304 0.00627529
Lt305 tm304 dm288 0.843241n
Ct305 dm288 0 0.156354p
Rp5a312 dp287 p5ra313 0.00516254
Rp5b312 dm288 p5rb314 0.00516254
Lp5a312 p5ra313 p5a310 0.926596n
Lp5b312 p5rb314 p5b311 0.926596n
Kp5312 Lp5a312 Lp5b312 0.22195
Cp5a312 p5a310 0 0.238684p
Cp5b312 p5b311 0 0.238684p
Cp5m312 p5a310 p5b311 0.0400109p
Rp5a317 p5a310 p5ra318 0.00516254
Rp5b317 p5b311 p5rb319 0.00516254
Lp5a317 p5ra318 p5a315 0.926596n
Lp5b317 p5rb319 p5b316 0.926596n
Kp5317 Lp5a317 Lp5b317 0.22195
Cp5a317 p5a315 0 0.238684p
Cp5b317 p5b316 0 0.238684p
Cp5m317 p5a315 p5b316 0.0400109p
Rp5a322 p5a315 p5ra323 0.00516254
Rp5b322 p5b316 p5rb324 0.00516254
Lp5a322 p5ra323 p5a320 0.926596n
Lp5b322 p5rb324 p5b321 0.926596n
Kp5322 Lp5a322 Lp5b322 0.22195
Cp5a322 p5a320 0 0.238684p
Cp5b322 p5b321 0 0.238684p
Cp5m322 p5a320 p5b321 0.0400109p
Rp5a327 p5a320 p5ra328 0.00516254
Rp5b327 p5b321 p5rb329 0.00516254
Lp5a327 p5ra328 p5a325 0.926596n
Lp5b327 p5rb329 p5b326 0.926596n
Kp5327 Lp5a327 Lp5b327 0.22195
Cp5a327 p5a325 0 0.238684p
Cp5b327 p5b326 0 0.238684p
Cp5m327 p5a325 p5b326 0.0400109p
Rp5a332 p5a325 p5ra333 0.00516254
Rp5b332 p5b326 p5rb334 0.00516254
Lp5a332 p5ra333 p5a330 0.926596n
Lp5b332 p5rb334 p5b331 0.926596n
Kp5332 Lp5a332 Lp5b332 0.22195
Cp5a332 p5a330 0 0.238684p
Cp5b332 p5b331 0 0.238684p
Cp5m332 p5a330 p5b331 0.0400109p
Rp5a335 p5a330 p5ra336 0.00516254
Rp5b335 p5b331 p5rb337 0.00516254
Lp5a335 p5ra336 dpx308 0.926596n
Lp5b335 p5rb337 dmx309 0.926596n
Kp5335 Lp5a335 Lp5b335 0.22195
Cp5a335 dpx308 0 0.238684p
Cp5b335 dmx309 0 0.238684p
Cp5m335 dpx308 dmx309 0.0400109p
Rt340 dpx308 tm338 0.00246864
Lt340 tm338 t339 0.448535n
Ct340 t339 0 0.129197p
Rt342 t339 tm341 0.00246864
Lt342 tm341 dp306 0.448535n
Ct342 dp306 0 0.129197p
Rj343 dmx309 dm307 1m
Lv345 dp306 u344 1.358n
Cv345 u344 0 0.4885p
Rt348 u344 tm346 0.00343926
Lt348 tm346 t347 0.46215n
Ct348 t347 0 0.0856918p
Rt350 t347 tm349 0.00343926
Lt350 tm349 rp_b 0.46215n
Ct350 rp_b 0 0.0856918p
Lv352 dm307 u351 1.358n
Cv352 u351 0 0.4885p
Rt355 u351 tm353 0.00342362
Lt355 tm353 t354 0.460048n
Ct355 t354 0 0.0853021p
Rt357 t354 tm356 0.00342362
Lt357 tm356 rm_b 0.460048n
Ct357 rm_b 0 0.0853021p
Cu10p conp 0 0.7p
Cu10m conm 0 0.7p
Rst361 conp stm359 0.00495442
Lst361 stm359 st360 0.665749n
Cst361 st360 0 0.123443p
Rst364 st360 stm362 0.00495442
Lst364 stm362 st363 0.665749n
Cst364 st363 0 0.123443p
Rst367 st363 stm365 0.00495442
Lst367 stm365 st366 0.665749n
Cst367 st366 0 0.123443p
Rst369 st366 stm368 0.00495442
Lst369 stm368 st358 0.665749n
Cst369 st358 0 0.123443p
Cst370 st358 0 0.3p
Rst374 conm stm372 0.00388229
Lst374 stm372 st373 0.521681n
Cst374 st373 0 0.0967302p
Rst376 st373 stm375 0.00388229
Lst376 stm375 st371 0.521681n
Cst376 st371 0 0.0967302p
Cst377 st371 0 0.3p
Cconp conp 0 0.6p
Cconm conm 0 0.6p
Rcbp0 conp cb378 4.6m
Lcbp0 cb378 cb379 4.68n
Ccbp0 cb379 0 2.3111p
Rcbp1 cb379 cb380 4.6m
Lcbp1 cb380 cb381 4.68n
Ccbp1 cb381 0 2.3111p
Rcbp2 cb381 cb382 4.6m
Lcbp2 cb382 cb383 4.68n
Ccbp2 cb383 0 2.3111p
Rcbp3 cb383 cb384 4.6m
Lcbp3 cb384 cb385 4.68n
Ccbp3 cb385 0 2.3111p
Rcbp4 cb385 cb386 4.6m
Lcbp4 cb386 cb387 4.68n
Ccbp4 cb387 0 2.3111p
Rcbp5 cb387 cb388 4.6m
Lcbp5 cb388 cb389 4.68n
Ccbp5 cb389 0 2.3111p
Rcbp6 cb389 cb390 4.6m
Lcbp6 cb390 cb391 4.68n
Ccbp6 cb391 0 2.3111p
Rcbp7 cb391 cb392 4.6m
Lcbp7 cb392 cb393 4.68n
Ccbp7 cb393 0 2.3111p
Rcbp8 cb393 cb394 4.6m
Lcbp8 cb394 cb395 4.68n
Ccbp8 cb395 0 2.3111p
Rcbp9 cb395 cb396 4.6m
Lcbp9 cb396 cb397 4.68n
Ccbp9 cb397 0 2.3111p
Rcbp10 cb397 cb398 4.6m
Lcbp10 cb398 cb399 4.68n
Ccbp10 cb399 0 2.3111p
Rcbp11 cb399 cb400 4.6m
Lcbp11 cb400 cb401 4.68n
Ccbp11 cb401 0 2.3111p
Rcbp12 cb401 cb402 4.6m
Lcbp12 cb402 cb403 4.68n
Ccbp12 cb403 0 2.3111p
Rcbp13 cb403 cb404 4.6m
Lcbp13 cb404 cb405 4.68n
Ccbp13 cb405 0 2.3111p
Rcbp14 cb405 cb406 4.6m
Lcbp14 cb406 cb407 4.68n
Ccbp14 cb407 0 2.3111p
Rcbp15 cb407 cb408 4.6m
Lcbp15 cb408 cb409 4.68n
Ccbp15 cb409 0 2.3111p
Rcbp16 cb409 cb410 4.6m
Lcbp16 cb410 cb411 4.68n
Ccbp16 cb411 0 2.3111p
Rcbp17 cb411 cb412 4.6m
Lcbp17 cb412 cb413 4.68n
Ccbp17 cb413 0 2.3111p
Rcbp18 cb413 cb414 4.6m
Lcbp18 cb414 cb415 4.68n
Ccbp18 cb415 0 2.3111p
Rcbp19 cb415 cb416 4.6m
Lcbp19 cb416 cb417 4.68n
Ccbp19 cb417 0 2.3111p
Rcbp20 cb417 cb418 4.6m
Lcbp20 cb418 cb419 4.68n
Ccbp20 cb419 0 2.3111p
Rcbp21 cb419 cb420 4.6m
Lcbp21 cb420 cb421 4.68n
Ccbp21 cb421 0 2.3111p
Rcbp22 cb421 cb422 4.6m
Lcbp22 cb422 cb423 4.68n
Ccbp22 cb423 0 2.3111p
Rcbp23 cb423 cb424 4.6m
Lcbp23 cb424 cb425 4.68n
Ccbp23 cb425 0 2.3111p
Rcbp24 cb425 cb426 4.6m
Lcbp24 cb426 cb427 4.68n
Ccbp24 cb427 0 2.3111p
Rcbp25 cb427 cb428 4.6m
Lcbp25 cb428 cb429 4.68n
Ccbp25 cb429 0 2.3111p
Rcbp26 cb429 cb430 4.6m
Lcbp26 cb430 cb431 4.68n
Ccbp26 cb431 0 2.3111p
Rcbp27 cb431 cb432 4.6m
Lcbp27 cb432 cb433 4.68n
Ccbp27 cb433 0 2.3111p
Rcbp28 cb433 cb434 4.6m
Lcbp28 cb434 cb435 4.68n
Ccbp28 cb435 0 2.3111p
Rcbp29 cb435 cb436 4.6m
Lcbp29 cb436 cb437 4.68n
Ccbp29 cb437 0 2.3111p
Rcbp30 cb437 cb438 4.6m
Lcbp30 cb438 cb439 4.68n
Ccbp30 cb439 0 2.3111p
Rcbp31 cb439 cb440 4.6m
Lcbp31 cb440 cb441 4.68n
Ccbp31 cb441 0 2.3111p
Rcbp32 cb441 cb442 4.6m
Lcbp32 cb442 cb443 4.68n
Ccbp32 cb443 0 2.3111p
Rcbp33 cb443 cb444 4.6m
Lcbp33 cb444 cb445 4.68n
Ccbp33 cb445 0 2.3111p
Rcbp34 cb445 cb446 4.6m
Lcbp34 cb446 cb447 4.68n
Ccbp34 cb447 0 2.3111p
Rcbp35 cb447 cb448 4.6m
Lcbp35 cb448 cb449 4.68n
Ccbp35 cb449 0 2.3111p
Rcbp36 cb449 cb450 4.6m
Lcbp36 cb450 cb451 4.68n
Ccbp36 cb451 0 2.3111p
Rcbp37 cb451 cb452 4.6m
Lcbp37 cb452 cb453 4.68n
Ccbp37 cb453 0 2.3111p
Rcbp38 cb453 cb454 4.6m
Lcbp38 cb454 cb455 4.68n
Ccbp38 cb455 0 2.3111p
Rcbp39 cb455 cb456 4.6m
Lcbp39 cb456 cb457 4.68n
Ccbp39 cb457 0 2.3111p
Rcbp40 cb457 cb458 4.6m
Lcbp40 cb458 cb459 4.68n
Ccbp40 cb459 0 2.3111p
Rcbp41 cb459 cb460 4.6m
Lcbp41 cb460 cb461 4.68n
Ccbp41 cb461 0 2.3111p
Rcbp42 cb461 cb462 4.6m
Lcbp42 cb462 cb463 4.68n
Ccbp42 cb463 0 2.3111p
Rcbp43 cb463 cb464 4.6m
Lcbp43 cb464 cb465 4.68n
Ccbp43 cb465 0 2.3111p
Rcbp44 cb465 cb466 4.6m
Lcbp44 cb466 cb467 4.68n
Ccbp44 cb467 0 2.3111p
Rcbp45 cb467 cb468 4.6m
Lcbp45 cb468 cb469 4.68n
Ccbp45 cb469 0 2.3111p
Rcbp46 cb469 cb470 4.6m
Lcbp46 cb470 cb471 4.68n
Ccbp46 cb471 0 2.3111p
Rcbp47 cb471 cb472 4.6m
Lcbp47 cb472 cb473 4.68n
Ccbp47 cb473 0 2.3111p
Rcbp48 cb473 cb474 4.6m
Lcbp48 cb474 cb475 4.68n
Ccbp48 cb475 0 2.3111p
Rcbp49 cb475 cb476 4.6m
Lcbp49 cb476 hp 4.68n
Ccbp49 hp 0 2.3111p
Rcbm0 conm cb477 4.6m
Lcbm0 cb477 cb478 4.68n
Ccbm0 cb478 0 2.3111p
Rcbm1 cb478 cb479 4.6m
Lcbm1 cb479 cb480 4.68n
Ccbm1 cb480 0 2.3111p
Rcbm2 cb480 cb481 4.6m
Lcbm2 cb481 cb482 4.68n
Ccbm2 cb482 0 2.3111p
Rcbm3 cb482 cb483 4.6m
Lcbm3 cb483 cb484 4.68n
Ccbm3 cb484 0 2.3111p
Rcbm4 cb484 cb485 4.6m
Lcbm4 cb485 cb486 4.68n
Ccbm4 cb486 0 2.3111p
Rcbm5 cb486 cb487 4.6m
Lcbm5 cb487 cb488 4.68n
Ccbm5 cb488 0 2.3111p
Rcbm6 cb488 cb489 4.6m
Lcbm6 cb489 cb490 4.68n
Ccbm6 cb490 0 2.3111p
Rcbm7 cb490 cb491 4.6m
Lcbm7 cb491 cb492 4.68n
Ccbm7 cb492 0 2.3111p
Rcbm8 cb492 cb493 4.6m
Lcbm8 cb493 cb494 4.68n
Ccbm8 cb494 0 2.3111p
Rcbm9 cb494 cb495 4.6m
Lcbm9 cb495 cb496 4.68n
Ccbm9 cb496 0 2.3111p
Rcbm10 cb496 cb497 4.6m
Lcbm10 cb497 cb498 4.68n
Ccbm10 cb498 0 2.3111p
Rcbm11 cb498 cb499 4.6m
Lcbm11 cb499 cb500 4.68n
Ccbm11 cb500 0 2.3111p
Rcbm12 cb500 cb501 4.6m
Lcbm12 cb501 cb502 4.68n
Ccbm12 cb502 0 2.3111p
Rcbm13 cb502 cb503 4.6m
Lcbm13 cb503 cb504 4.68n
Ccbm13 cb504 0 2.3111p
Rcbm14 cb504 cb505 4.6m
Lcbm14 cb505 cb506 4.68n
Ccbm14 cb506 0 2.3111p
Rcbm15 cb506 cb507 4.6m
Lcbm15 cb507 cb508 4.68n
Ccbm15 cb508 0 2.3111p
Rcbm16 cb508 cb509 4.6m
Lcbm16 cb509 cb510 4.68n
Ccbm16 cb510 0 2.3111p
Rcbm17 cb510 cb511 4.6m
Lcbm17 cb511 cb512 4.68n
Ccbm17 cb512 0 2.3111p
Rcbm18 cb512 cb513 4.6m
Lcbm18 cb513 cb514 4.68n
Ccbm18 cb514 0 2.3111p
Rcbm19 cb514 cb515 4.6m
Lcbm19 cb515 cb516 4.68n
Ccbm19 cb516 0 2.3111p
Rcbm20 cb516 cb517 4.6m
Lcbm20 cb517 cb518 4.68n
Ccbm20 cb518 0 2.3111p
Rcbm21 cb518 cb519 4.6m
Lcbm21 cb519 cb520 4.68n
Ccbm21 cb520 0 2.3111p
Rcbm22 cb520 cb521 4.6m
Lcbm22 cb521 cb522 4.68n
Ccbm22 cb522 0 2.3111p
Rcbm23 cb522 cb523 4.6m
Lcbm23 cb523 cb524 4.68n
Ccbm23 cb524 0 2.3111p
Rcbm24 cb524 cb525 4.6m
Lcbm24 cb525 cb526 4.68n
Ccbm24 cb526 0 2.3111p
Rcbm25 cb526 cb527 4.6m
Lcbm25 cb527 cb528 4.68n
Ccbm25 cb528 0 2.3111p
Rcbm26 cb528 cb529 4.6m
Lcbm26 cb529 cb530 4.68n
Ccbm26 cb530 0 2.3111p
Rcbm27 cb530 cb531 4.6m
Lcbm27 cb531 cb532 4.68n
Ccbm27 cb532 0 2.3111p
Rcbm28 cb532 cb533 4.6m
Lcbm28 cb533 cb534 4.68n
Ccbm28 cb534 0 2.3111p
Rcbm29 cb534 cb535 4.6m
Lcbm29 cb535 cb536 4.68n
Ccbm29 cb536 0 2.3111p
Rcbm30 cb536 cb537 4.6m
Lcbm30 cb537 cb538 4.68n
Ccbm30 cb538 0 2.3111p
Rcbm31 cb538 cb539 4.6m
Lcbm31 cb539 cb540 4.68n
Ccbm31 cb540 0 2.3111p
Rcbm32 cb540 cb541 4.6m
Lcbm32 cb541 cb542 4.68n
Ccbm32 cb542 0 2.3111p
Rcbm33 cb542 cb543 4.6m
Lcbm33 cb543 cb544 4.68n
Ccbm33 cb544 0 2.3111p
Rcbm34 cb544 cb545 4.6m
Lcbm34 cb545 cb546 4.68n
Ccbm34 cb546 0 2.3111p
Rcbm35 cb546 cb547 4.6m
Lcbm35 cb547 cb548 4.68n
Ccbm35 cb548 0 2.3111p
Rcbm36 cb548 cb549 4.6m
Lcbm36 cb549 cb550 4.68n
Ccbm36 cb550 0 2.3111p
Rcbm37 cb550 cb551 4.6m
Lcbm37 cb551 cb552 4.68n
Ccbm37 cb552 0 2.3111p
Rcbm38 cb552 cb553 4.6m
Lcbm38 cb553 cb554 4.68n
Ccbm38 cb554 0 2.3111p
Rcbm39 cb554 cb555 4.6m
Lcbm39 cb555 cb556 4.68n
Ccbm39 cb556 0 2.3111p
Rcbm40 cb556 cb557 4.6m
Lcbm40 cb557 cb558 4.68n
Ccbm40 cb558 0 2.3111p
Rcbm41 cb558 cb559 4.6m
Lcbm41 cb559 cb560 4.68n
Ccbm41 cb560 0 2.3111p
Rcbm42 cb560 cb561 4.6m
Lcbm42 cb561 cb562 4.68n
Ccbm42 cb562 0 2.3111p
Rcbm43 cb562 cb563 4.6m
Lcbm43 cb563 cb564 4.68n
Ccbm43 cb564 0 2.3111p
Rcbm44 cb564 cb565 4.6m
Lcbm44 cb565 cb566 4.68n
Ccbm44 cb566 0 2.3111p
Rcbm45 cb566 cb567 4.6m
Lcbm45 cb567 cb568 4.68n
Ccbm45 cb568 0 2.3111p
Rcbm46 cb568 cb569 4.6m
Lcbm46 cb569 cb570 4.68n
Ccbm46 cb570 0 2.3111p
Rcbm47 cb570 cb571 4.6m
Lcbm47 cb571 cb572 4.68n
Ccbm47 cb572 0 2.3111p
Rcbm48 cb572 cb573 4.6m
Lcbm48 cb573 cb574 4.68n
Ccbm48 cb574 0 2.3111p
Rcbm49 cb574 cb575 4.6m
Lcbm49 cb575 hm 4.68n
Ccbm49 hm 0 2.3111p
Chp hp 0 20.0p
Chm hm 0 20.0p
Rhp hp 0 15k
Rhm hm 0 15k
.options method=gear reltol=2e-3
.tran 0.1n 5333.3n 0 0.2n
.control
set wr_singlescale
set wr_vecnames
set numdgt=7
run

wrdata /out/usb_03_device_tx_4ns.txt v(hp) v(hm) v(conp) v(conm)
.endc
.end
