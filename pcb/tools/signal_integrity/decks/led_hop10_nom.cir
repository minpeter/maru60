* led_hop10_nom: SK6805 DOUT (assumed 100 ohm, 10 ns) -> 100 ohm in series -> routed hop -> DIN 5 pF
Vsrc src 0 PWL(0.0000n 0 100.0000n 0 110.0000n 4 400.0000n 4 410.0000n 0 1300.0000n 0 1310.0000n 4 2200.0000n 4 2210.0000n 0 2500.0000n 0 2510.0000n 4 2800.0000n 4 2810.0000n 0 3700.0000n 0 3710.0000n 4 4600.0000n 4 4610.0000n 0)
Rdrv src dout 100.0
Cdout dout 0 2p
Rt2 dout tm1 0.00488136
Lt2 tm1 rs_a 0.655932n
Ct2 rs_a 0 0.121623p
Rser rs_a rs_b 100
Cser rs_b 0 0.1p
Rt6 rs_b tm4 0.00541815
Lt6 tm4 t5 0.728064n
Ct6 t5 0 0.134998p
Rt9 t5 tm7 0.00541815
Lt9 tm7 t8 0.728064n
Ct9 t8 0 0.134998p
Rt12 t8 tm10 0.00541815
Lt12 tm10 t11 0.728064n
Ct12 t11 0 0.134998p
Rt15 t11 tm13 0.00541815
Lt15 tm13 t14 0.728064n
Ct15 t14 0 0.134998p
Rt17 t14 tm16 0.00541815
Lt17 tm16 p3 0.728064n
Ct17 p3 0 0.134998p
Lv19 p3 v18 1.358n
Cv19 v18 0 0.4885p
Rt23 v18 tm21 0.00605096
Lt23 tm21 t22 0.813096n
Ct23 t22 0 0.150764p
Rt26 t22 tm24 0.00605096
Lt26 tm24 t25 0.813096n
Ct26 t25 0 0.150764p
Rt29 t25 tm27 0.00605096
Lt29 tm27 t28 0.813096n
Ct29 t28 0 0.150764p
Rt32 t28 tm30 0.00605096
Lt32 tm30 t31 0.813096n
Ct32 t31 0 0.150764p
Rt35 t31 tm33 0.00605096
Lt35 tm33 t34 0.813096n
Ct35 t34 0 0.150764p
Rt38 t34 tm36 0.00605096
Lt38 tm36 t37 0.813096n
Ct38 t37 0 0.150764p
Rt41 t37 tm39 0.00605096
Lt41 tm39 t40 0.813096n
Ct41 t40 0 0.150764p
Rt44 t40 tm42 0.00605096
Lt44 tm42 t43 0.813096n
Ct44 t43 0 0.150764p
Rt46 t43 tm45 0.00605096
Lt46 tm45 p20 0.813096n
Ct46 p20 0 0.150764p
Lv48 p20 v47 1.358n
Cv48 v47 0 0.4885p
Rt52 v47 tm50 0.00509897
Lt52 tm50 t51 0.685173n
Ct52 t51 0 0.127045p
Rt54 t51 tm53 0.00509897
Lt54 tm53 p49 0.685173n
Ct54 p49 0 0.127045p
Lv56 p49 v55 1.358n
Cv56 v55 0 0.4885p
Rt60 v55 tm58 0.00647931
Lt60 tm58 t59 0.870656n
Ct60 t59 0 0.161437p
Rt63 t59 tm61 0.00647931
Lt63 tm61 t62 0.870656n
Ct63 t62 0 0.161437p
Rt66 t62 tm64 0.00647931
Lt66 tm64 t65 0.870656n
Ct66 t65 0 0.161437p
Rt69 t65 tm67 0.00647931
Lt69 tm67 t68 0.870656n
Ct69 t68 0 0.161437p
Rt72 t68 tm70 0.00647931
Lt72 tm70 t71 0.870656n
Ct72 t71 0 0.161437p
Rt75 t71 tm73 0.00647931
Lt75 tm73 t74 0.870656n
Ct75 t74 0 0.161437p
Rt78 t74 tm76 0.00647931
Lt78 tm76 t77 0.870656n
Ct78 t77 0 0.161437p
Rt81 t77 tm79 0.00647931
Lt81 tm79 t80 0.870656n
Ct81 t80 0 0.161437p
Rt84 t80 tm82 0.00647931
Lt84 tm82 t83 0.870656n
Ct84 t83 0 0.161437p
Rt87 t83 tm85 0.00647931
Lt87 tm85 t86 0.870656n
Ct87 t86 0 0.161437p
Rt90 t86 tm88 0.00647931
Lt90 tm88 t89 0.870656n
Ct90 t89 0 0.161437p
Rt93 t89 tm91 0.00647931
Lt93 tm91 t92 0.870656n
Ct93 t92 0 0.161437p
Rt96 t92 tm94 0.00647931
Lt96 tm94 t95 0.870656n
Ct96 t95 0 0.161437p
Rt99 t95 tm97 0.00647931
Lt99 tm97 t98 0.870656n
Ct99 t98 0 0.161437p
Rt101 t98 tm100 0.00647931
Lt101 tm100 p57 0.870656n
Ct101 p57 0 0.161437p
Rt104 p57 tm103 0.00180333
Lt104 tm103 p102 0.375687n
Ct104 p102 0 0.137062p
Lv106 p102 v105 1.358n
Cv106 v105 0 0.4885p
Rt109 v105 tm108 0.00269312
Lt109 tm108 p107 0.428003n
Ct109 p107 0 0.101958p
Rs112 p107 sm111 0.00130229
Ls112 sm111 stubend110 0.206966n
Cs112 stubend110 0 0.0493031p
Cs113 stubend110 0 0.15p
Rt115 p107 tm114 0.000177314
Lt115 tm114 din 0.0281796n
Ct115 din 0 0.00671292p
Cin din 0 5p
.tran 0.1n 5000n 0 0.2n
.control
set wr_singlescale
set wr_vecnames
set numdgt=7
run

wrdata /out/led_hop10_nom.txt v(dout) v(din)
.endc
.end
