* matrix: 6 key(s) of the same row closed, RON 125 ohm, RPU 86 k, 27 C
.options temp=27 method=gear
Vdd vdd 0 3.3
.model D4148 D(IS=2.52n RS=0.568 N=1.752 CJO=0.9p M=0.4 VJ=0.7 TT=4n BV=100 IBV=1u)
.model SWROW SW(RON=1 ROFF=1G VT=0.5 VH=0.01)
Vsel sel 0 PWL(0 0 100n 0 101.5n 1 2000n 1 2001.5n 0)
Srow rowpin rdrv sel 0 SWROW
Rron rdrv 0 124
Rpur vdd rowpin 86000.0
Cpinr rowpin 0 5.0p
Rr0 rowpin rw1x 0.066568
Lr0 rw1x rw1 10.579n
Cr0 rw1 0 5.7917p
Rr1 rw1 rw2x 0.066568
Lr1 rw2x rw2 10.579n
Cr1 rw2 0 5.7917p
Rr2 rw2 rw3x 0.066568
Lr2 rw3x rw3 10.579n
Cr2 rw3 0 5.7917p
Rr3 rw3 rw4x 0.066568
Lr3 rw4x rw4 10.579n
Cr3 rw4 0 5.7917p
Rr4 rw4 rw5x 0.066568
Lr4 rw5x rw5 10.579n
Cr4 rw5 0 5.7917p
Rr5 rw5 rw6x 0.066568
Lr5 rw6x rw6 10.579n
Cr5 rw6 0 5.7917p
Rr6 rw6 rw7x 0.066568
Lr6 rw7x rw7 10.579n
Cr6 rw7 0 5.7917p
Rr7 rw7 rw8x 0.066568
Lr7 rw8x rw8 10.579n
Cr7 rw8 0 5.7917p
Rr8 rw8 rw9x 0.066568
Lr8 rw9x rw9 10.579n
Cr8 rw9 0 5.7917p
Rr9 rw9 rw10x 0.066568
Lr9 rw10x rw10 10.579n
Cr9 rw10 0 5.7917p
Rr10 rw10 rw11x 0.066568
Lr10 rw11x rw11 10.579n
Cr10 rw11 0 5.7917p
Rr11 rw11 rowfarx 0.066568
Lr11 rowfarx rowfar 10.579n
Cr11 rowfar 0 5.7917p
D0 key0 rowfar D4148
Ckey0 key0 0 8.8p
Rsw0 key0 colfar0 0.2
Rpuc0 vdd colpin0 86000.0
Cpinc0 colpin0 0 5.0p
Rc0_0 colfar0 c0_0x 0.052583
Lc0_0 c0_0x c0_0 8.3567n
Cc0_0 c0_0 0 3.6733p
Rc0_1 c0_0 c0_1x 0.052583
Lc0_1 c0_1x c0_1 8.3567n
Cc0_1 c0_1 0 3.6733p
Rc0_2 c0_1 c0_2x 0.052583
Lc0_2 c0_2x c0_2 8.3567n
Cc0_2 c0_2 0 3.6733p
Rc0_3 c0_2 c0_3x 0.052583
Lc0_3 c0_3x c0_3 8.3567n
Cc0_3 c0_3 0 3.6733p
Rc0_4 c0_3 c0_4x 0.052583
Lc0_4 c0_4x c0_4 8.3567n
Cc0_4 c0_4 0 3.6733p
Rc0_5 c0_4 c0_5x 0.052583
Lc0_5 c0_5x c0_5 8.3567n
Cc0_5 c0_5 0 3.6733p
Rc0_6 c0_5 c0_6x 0.052583
Lc0_6 c0_6x c0_6 8.3567n
Cc0_6 c0_6 0 3.6733p
Rc0_7 c0_6 c0_7x 0.052583
Lc0_7 c0_7x c0_7 8.3567n
Cc0_7 c0_7 0 3.6733p
Rc0_8 c0_7 c0_8x 0.052583
Lc0_8 c0_8x c0_8 8.3567n
Cc0_8 c0_8 0 3.6733p
Rc0_9 c0_8 c0_9x 0.052583
Lc0_9 c0_9x c0_9 8.3567n
Cc0_9 c0_9 0 3.6733p
Rc0_10 c0_9 c0_10x 0.052583
Lc0_10 c0_10x c0_10 8.3567n
Cc0_10 c0_10 0 3.6733p
Rc0_11 c0_10 colpin0x 0.052583
Lc0_11 colpin0x colpin0 8.3567n
Cc0_11 colpin0 0 3.6733p
D1 key1 rw4 D4148
Ckey1 key1 0 8.8p
Rsw1 key1 colfar1 0.2
Rpuc1 vdd colpin1 86000.0
Cpinc1 colpin1 0 5.0p
Rc1_0 colfar1 c1_0x 0.056862
Lc1_0 c1_0x c1_0 9.0369n
Cc1_0 c1_0 0 3.4092p
Rc1_1 c1_0 c1_1x 0.056862
Lc1_1 c1_1x c1_1 9.0369n
Cc1_1 c1_1 0 3.4092p
Rc1_2 c1_1 c1_2x 0.056862
Lc1_2 c1_2x c1_2 9.0369n
Cc1_2 c1_2 0 3.4092p
Rc1_3 c1_2 c1_3x 0.056862
Lc1_3 c1_3x c1_3 9.0369n
Cc1_3 c1_3 0 3.4092p
Rc1_4 c1_3 c1_4x 0.056862
Lc1_4 c1_4x c1_4 9.0369n
Cc1_4 c1_4 0 3.4092p
Rc1_5 c1_4 c1_5x 0.056862
Lc1_5 c1_5x c1_5 9.0369n
Cc1_5 c1_5 0 3.4092p
Rc1_6 c1_5 c1_6x 0.056862
Lc1_6 c1_6x c1_6 9.0369n
Cc1_6 c1_6 0 3.4092p
Rc1_7 c1_6 c1_7x 0.056862
Lc1_7 c1_7x c1_7 9.0369n
Cc1_7 c1_7 0 3.4092p
Rc1_8 c1_7 c1_8x 0.056862
Lc1_8 c1_8x c1_8 9.0369n
Cc1_8 c1_8 0 3.4092p
Rc1_9 c1_8 c1_9x 0.056862
Lc1_9 c1_9x c1_9 9.0369n
Cc1_9 c1_9 0 3.4092p
Rc1_10 c1_9 c1_10x 0.056862
Lc1_10 c1_10x c1_10 9.0369n
Cc1_10 c1_10 0 3.4092p
Rc1_11 c1_10 colpin1x 0.056862
Lc1_11 colpin1x colpin1 9.0369n
Cc1_11 colpin1 0 3.4092p
D2 key2 rw7 D4148
Ckey2 key2 0 8.8p
Rsw2 key2 colfar2 0.2
Rpuc2 vdd colpin2 86000.0
Cpinc2 colpin2 0 5.0p
Rc2_0 colfar2 c2_0x 0.045969
Lc2_0 c2_0x c2_0 7.3056n
Cc2_0 c2_0 0 2.8508p
Rc2_1 c2_0 c2_1x 0.045969
Lc2_1 c2_1x c2_1 7.3056n
Cc2_1 c2_1 0 2.8508p
Rc2_2 c2_1 c2_2x 0.045969
Lc2_2 c2_2x c2_2 7.3056n
Cc2_2 c2_2 0 2.8508p
Rc2_3 c2_2 c2_3x 0.045969
Lc2_3 c2_3x c2_3 7.3056n
Cc2_3 c2_3 0 2.8508p
Rc2_4 c2_3 c2_4x 0.045969
Lc2_4 c2_4x c2_4 7.3056n
Cc2_4 c2_4 0 2.8508p
Rc2_5 c2_4 c2_5x 0.045969
Lc2_5 c2_5x c2_5 7.3056n
Cc2_5 c2_5 0 2.8508p
Rc2_6 c2_5 c2_6x 0.045969
Lc2_6 c2_6x c2_6 7.3056n
Cc2_6 c2_6 0 2.8508p
Rc2_7 c2_6 c2_7x 0.045969
Lc2_7 c2_7x c2_7 7.3056n
Cc2_7 c2_7 0 2.8508p
Rc2_8 c2_7 c2_8x 0.045969
Lc2_8 c2_8x c2_8 7.3056n
Cc2_8 c2_8 0 2.8508p
Rc2_9 c2_8 c2_9x 0.045969
Lc2_9 c2_9x c2_9 7.3056n
Cc2_9 c2_9 0 2.8508p
Rc2_10 c2_9 c2_10x 0.045969
Lc2_10 c2_10x c2_10 7.3056n
Cc2_10 c2_10 0 2.8508p
Rc2_11 c2_10 colpin2x 0.045969
Lc2_11 colpin2x colpin2 7.3056n
Cc2_11 colpin2 0 2.8508p
D3 key3 rw10 D4148
Ckey3 key3 0 8.8p
Rsw3 key3 colfar3 0.2
Rpuc3 vdd colpin3 86000.0
Cpinc3 colpin3 0 5.0p
Rc3_0 colfar3 c3_0x 0.02967
Lc3_0 c3_0x c3_0 4.7153n
Cc3_0 c3_0 0 2.8167p
Rc3_1 c3_0 c3_1x 0.02967
Lc3_1 c3_1x c3_1 4.7153n
Cc3_1 c3_1 0 2.8167p
Rc3_2 c3_1 c3_2x 0.02967
Lc3_2 c3_2x c3_2 4.7153n
Cc3_2 c3_2 0 2.8167p
Rc3_3 c3_2 c3_3x 0.02967
Lc3_3 c3_3x c3_3 4.7153n
Cc3_3 c3_3 0 2.8167p
Rc3_4 c3_3 c3_4x 0.02967
Lc3_4 c3_4x c3_4 4.7153n
Cc3_4 c3_4 0 2.8167p
Rc3_5 c3_4 c3_5x 0.02967
Lc3_5 c3_5x c3_5 4.7153n
Cc3_5 c3_5 0 2.8167p
Rc3_6 c3_5 c3_6x 0.02967
Lc3_6 c3_6x c3_6 4.7153n
Cc3_6 c3_6 0 2.8167p
Rc3_7 c3_6 c3_7x 0.02967
Lc3_7 c3_7x c3_7 4.7153n
Cc3_7 c3_7 0 2.8167p
Rc3_8 c3_7 c3_8x 0.02967
Lc3_8 c3_8x c3_8 4.7153n
Cc3_8 c3_8 0 2.8167p
Rc3_9 c3_8 c3_9x 0.02967
Lc3_9 c3_9x c3_9 4.7153n
Cc3_9 c3_9 0 2.8167p
Rc3_10 c3_9 c3_10x 0.02967
Lc3_10 c3_10x c3_10 4.7153n
Cc3_10 c3_10 0 2.8167p
Rc3_11 c3_10 colpin3x 0.02967
Lc3_11 colpin3x colpin3 4.7153n
Cc3_11 colpin3 0 2.8167p
D4 key4 rw2 D4148
Ckey4 key4 0 8.8p
Rsw4 key4 colfar4 0.2
Rpuc4 vdd colpin4 86000.0
Cpinc4 colpin4 0 5.0p
Rc4_0 colfar4 c4_0x 0.056228
Lc4_0 c4_0x c4_0 8.936n
Cc4_0 c4_0 0 2.6642p
Rc4_1 c4_0 c4_1x 0.056228
Lc4_1 c4_1x c4_1 8.936n
Cc4_1 c4_1 0 2.6642p
Rc4_2 c4_1 c4_2x 0.056228
Lc4_2 c4_2x c4_2 8.936n
Cc4_2 c4_2 0 2.6642p
Rc4_3 c4_2 c4_3x 0.056228
Lc4_3 c4_3x c4_3 8.936n
Cc4_3 c4_3 0 2.6642p
Rc4_4 c4_3 c4_4x 0.056228
Lc4_4 c4_4x c4_4 8.936n
Cc4_4 c4_4 0 2.6642p
Rc4_5 c4_4 c4_5x 0.056228
Lc4_5 c4_5x c4_5 8.936n
Cc4_5 c4_5 0 2.6642p
Rc4_6 c4_5 c4_6x 0.056228
Lc4_6 c4_6x c4_6 8.936n
Cc4_6 c4_6 0 2.6642p
Rc4_7 c4_6 c4_7x 0.056228
Lc4_7 c4_7x c4_7 8.936n
Cc4_7 c4_7 0 2.6642p
Rc4_8 c4_7 c4_8x 0.056228
Lc4_8 c4_8x c4_8 8.936n
Cc4_8 c4_8 0 2.6642p
Rc4_9 c4_8 c4_9x 0.056228
Lc4_9 c4_9x c4_9 8.936n
Cc4_9 c4_9 0 2.6642p
Rc4_10 c4_9 c4_10x 0.056228
Lc4_10 c4_10x c4_10 8.936n
Cc4_10 c4_10 0 2.6642p
Rc4_11 c4_10 colpin4x 0.056228
Lc4_11 colpin4x colpin4 8.936n
Cc4_11 colpin4 0 2.6642p
D5 key5 rw5 D4148
Ckey5 key5 0 8.8p
Rsw5 key5 colfar5 0.2
Rpuc5 vdd colpin5 86000.0
Cpinc5 colpin5 0 5.0p
Rc5_0 colfar5 c5_0x 0.043266
Lc5_0 c5_0x c5_0 6.8761n
Cc5_0 c5_0 0 2.6108p
Rc5_1 c5_0 c5_1x 0.043266
Lc5_1 c5_1x c5_1 6.8761n
Cc5_1 c5_1 0 2.6108p
Rc5_2 c5_1 c5_2x 0.043266
Lc5_2 c5_2x c5_2 6.8761n
Cc5_2 c5_2 0 2.6108p
Rc5_3 c5_2 c5_3x 0.043266
Lc5_3 c5_3x c5_3 6.8761n
Cc5_3 c5_3 0 2.6108p
Rc5_4 c5_3 c5_4x 0.043266
Lc5_4 c5_4x c5_4 6.8761n
Cc5_4 c5_4 0 2.6108p
Rc5_5 c5_4 c5_5x 0.043266
Lc5_5 c5_5x c5_5 6.8761n
Cc5_5 c5_5 0 2.6108p
Rc5_6 c5_5 c5_6x 0.043266
Lc5_6 c5_6x c5_6 6.8761n
Cc5_6 c5_6 0 2.6108p
Rc5_7 c5_6 c5_7x 0.043266
Lc5_7 c5_7x c5_7 6.8761n
Cc5_7 c5_7 0 2.6108p
Rc5_8 c5_7 c5_8x 0.043266
Lc5_8 c5_8x c5_8 6.8761n
Cc5_8 c5_8 0 2.6108p
Rc5_9 c5_8 c5_9x 0.043266
Lc5_9 c5_9x c5_9 6.8761n
Cc5_9 c5_9 0 2.6108p
Rc5_10 c5_9 c5_10x 0.043266
Lc5_10 c5_10x c5_10 6.8761n
Cc5_10 c5_10 0 2.6108p
Rc5_11 c5_10 colpin5x 0.043266
Lc5_11 colpin5x colpin5 6.8761n
Cc5_11 colpin5 0 2.6108p
.tran 0.2n 40u 0 20n
.control
set wr_singlescale
set wr_vecnames
set numdgt=7
run

wrdata /out/matrix_limit_6k_125.txt v(rowpin) v(rowfar) v(colpin0) v(sel)
.endc
.end
