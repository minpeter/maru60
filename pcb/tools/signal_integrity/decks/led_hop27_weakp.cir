* led_hop27_weakp: SK6805 DOUT (assumed 1000 ohm, 30 ns) -> 100 ohm in series -> routed hop -> DIN 15 pF
Vsrc src 0 PWL(0.0000n 0 100.0000n 0 130.0000n 4 400.0000n 4 430.0000n 0 1300.0000n 0 1330.0000n 4 2200.0000n 4 2230.0000n 0 2500.0000n 0 2530.0000n 4 2800.0000n 4 2830.0000n 0 3700.0000n 0 3730.0000n 4 4600.0000n 4 4630.0000n 0)
Rdrv src dout 1000.0
Cdout dout 0 2p
Rt4 dout tm2 0.00361158
Lt4 tm2 t3 0.656199n
Ct4 t3 0 0.189013p
Rt7 t3 tm5 0.00361158
Lt7 tm5 t6 0.656199n
Ct7 t6 0 0.189013p
Rt10 t6 tm8 0.00361158
Lt10 tm8 t9 0.656199n
Ct10 t9 0 0.189013p
Rt13 t9 tm11 0.00361158
Lt13 tm11 t12 0.656199n
Ct13 t12 0 0.189013p
Rt16 t12 tm14 0.00361158
Lt16 tm14 t15 0.656199n
Ct16 t15 0 0.189013p
Rt19 t15 tm17 0.00361158
Lt19 tm17 t18 0.656199n
Ct19 t18 0 0.189013p
Rt22 t18 tm20 0.00361158
Lt22 tm20 t21 0.656199n
Ct22 t21 0 0.189013p
Rt25 t21 tm23 0.00361158
Lt25 tm23 t24 0.656199n
Ct25 t24 0 0.189013p
Rt28 t24 tm26 0.00361158
Lt28 tm26 t27 0.656199n
Ct28 t27 0 0.189013p
Rt31 t27 tm29 0.00361158
Lt31 tm29 t30 0.656199n
Ct31 t30 0 0.189013p
Rt34 t30 tm32 0.00361158
Lt34 tm32 t33 0.656199n
Ct34 t33 0 0.189013p
Rt36 t33 tm35 0.00361158
Lt36 tm35 p1 0.656199n
Ct36 p1 0 0.189013p
Rt39 p1 tm38 6.27234e-06
Lt39 tm38 p37 0.000996832n
Ct39 p37 0 0.000237464p
Rs43 p37 sm41 0.00430442
Ls43 sm41 s42 0.68408n
Cs43 s42 0 0.162961p
Rs46 s42 sm44 0.00430442
Ls46 sm44 s45 0.68408n
Cs46 s45 0 0.162961p
Rs49 s45 sm47 0.00430442
Ls49 sm47 s48 0.68408n
Cs49 s48 0 0.162961p
Rs52 s48 sm50 0.00430442
Ls52 sm50 s51 0.68408n
Cs52 s51 0 0.162961p
Rs54 s51 sm53 0.00430442
Ls54 sm53 stubend40 0.68408n
Cs54 stubend40 0 0.162961p
Cs55 stubend40 0 0.15p
Rt58 p37 tm57 1.11023e-05
Lt58 tm57 p56 0.00176443n
Ct58 p56 0 0.00042032p
Rt61 p56 tm60 0.0044698
Lt61 tm60 p59 0.710362n
Ct61 p59 0 0.169222p
Rt65 p59 tm63 0.00405429
Lt65 tm63 t64 0.644327n
Ct65 t64 0 0.153491p
Rt67 t64 tm66 0.00405429
Lt67 tm66 p62 0.644327n
Ct67 p62 0 0.153491p
Rt71 p62 tm69 0.00319429
Lt71 tm69 t70 0.507652n
Ct71 t70 0 0.120932p
Rt73 t70 tm72 0.00319429
Lt73 tm72 p68 0.507652n
Ct73 p68 0 0.120932p
Rt76 p68 tm75 0.00355924
Lt76 tm75 p74 0.565652n
Ct76 p74 0 0.134749p
Lv78 p74 v77 1.358n
Cv78 v77 0 0.4885p
Rt80 v77 tm79 0.00393119
Lt80 tm79 rs_a 0.624764n
Ct80 rs_a 0 0.148831p
Rser rs_a rs_b 100
Cser rs_b 0 0.1p
Rt83 rs_b tm82 0.001204
Lt83 tm82 p81 0.191346n
Ct83 p81 0 0.0455821p
Rs87 p81 sm85 0.00420786
Ls87 sm85 s86 0.668733n
Cs87 s86 0 0.159305p
Rs90 s86 sm88 0.00420786
Ls90 sm88 s89 0.668733n
Cs90 s89 0 0.159305p
Rs93 s89 sm91 0.00420786
Ls93 sm91 s92 0.668733n
Cs93 s92 0 0.159305p
Rs95 s92 sm94 0.00420786
Ls95 sm94 stubend84 0.668733n
Cs95 stubend84 0 0.159305p
Cs96 stubend84 0 0.4885p
Cs97 stubend84 0 0.15p
Rt100 p81 tm99 9.98773e-06
Lt100 tm99 p98 0.0015873n
Ct100 p98 0 0.000378125p
Rt103 p98 tm101 0.00385771
Lt103 tm101 t102 0.700919n
Ct103 t102 0 0.201895p
Rt106 t102 tm104 0.00385771
Lt106 tm104 t105 0.700919n
Ct106 t105 0 0.201895p
Rt109 t105 tm107 0.00385771
Lt109 tm107 t108 0.700919n
Ct109 t108 0 0.201895p
Rt112 t108 tm110 0.00385771
Lt112 tm110 t111 0.700919n
Ct112 t111 0 0.201895p
Rt115 t111 tm113 0.00385771
Lt115 tm113 t114 0.700919n
Ct115 t114 0 0.201895p
Rt118 t114 tm116 0.00385771
Lt118 tm116 t117 0.700919n
Ct118 t117 0 0.201895p
Rt121 t117 tm119 0.00385771
Lt121 tm119 t120 0.700919n
Ct121 t120 0 0.201895p
Rt123 t120 tm122 0.00385771
Lt123 tm122 din 0.700919n
Ct123 din 0 0.201895p
Cin din 0 15p
.tran 0.1n 5000n 0 0.2n
.control
set wr_singlescale
set wr_vecnames
set numdgt=7
run

wrdata /out/led_hop27_weakp.txt v(dout) v(din)
.endc
.end
