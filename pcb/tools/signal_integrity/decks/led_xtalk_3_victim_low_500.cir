* led_xtalk_3_victim_low_500: matrix line beside a quiet LED data hop, 80 mm at 0.15 mm gap
Vq q 0 0.0
Rq q v0 600.0
Vagg a 0 PWL(0 0 20n 0 21n 3.3 120n 3.3 121n 0)
Ragg a a0 40
Rt3 v0 tm1 0.00486442
Lt3 tm1 t2 0.773077n
Ct3 t2 0 0.184162p
Rt6 t2 tm4 0.00486442
Lt6 tm4 t5 0.773077n
Ct6 t5 0 0.184162p
Rt9 t5 tm7 0.00486442
Lt9 tm7 t8 0.773077n
Ct9 t8 0 0.184162p
Rt12 t8 tm10 0.00486442
Lt12 tm10 t11 0.773077n
Ct12 t11 0 0.184162p
Rt15 t11 tm13 0.00486442
Lt15 tm13 t14 0.773077n
Ct15 t14 0 0.184162p
Rt18 t14 tm16 0.00486442
Lt18 tm16 t17 0.773077n
Ct18 t17 0 0.184162p
Rt21 t17 tm19 0.00486442
Lt21 tm19 t20 0.773077n
Ct21 t20 0 0.184162p
Rt24 t20 tm22 0.00486442
Lt24 tm22 t23 0.773077n
Ct24 t23 0 0.184162p
Rt27 t23 tm25 0.00486442
Lt27 tm25 t26 0.773077n
Ct27 t26 0 0.184162p
Rt30 t26 tm28 0.00486442
Lt30 tm28 t29 0.773077n
Ct30 t29 0 0.184162p
Rt33 t29 tm31 0.00486442
Lt33 tm31 t32 0.773077n
Ct33 t32 0 0.184162p
Rt36 t32 tm34 0.00486442
Lt36 tm34 t35 0.773077n
Ct36 t35 0 0.184162p
Rt39 t35 tm37 0.00486442
Lt39 tm37 t38 0.773077n
Ct39 t38 0 0.184162p
Rt42 t38 tm40 0.00486442
Lt42 tm40 t41 0.773077n
Ct42 t41 0 0.184162p
Rt45 t41 tm43 0.00486442
Lt45 tm43 t44 0.773077n
Ct45 t44 0 0.184162p
Rt48 t44 tm46 0.00486442
Lt48 tm46 t47 0.773077n
Ct48 t47 0 0.184162p
Rt51 t47 tm49 0.00486442
Lt51 tm49 t50 0.773077n
Ct51 t50 0 0.184162p
Rt54 t50 tm52 0.00486442
Lt54 tm52 t53 0.773077n
Ct54 t53 0 0.184162p
Rt57 t53 tm55 0.00486442
Lt57 tm55 t56 0.773077n
Ct57 t56 0 0.184162p
Rt60 t56 tm58 0.00486442
Lt60 tm58 t59 0.773077n
Ct60 t59 0 0.184162p
Rt63 t59 tm61 0.00486442
Lt63 tm61 t62 0.773077n
Ct63 t62 0 0.184162p
Rt66 t62 tm64 0.00486442
Lt66 tm64 t65 0.773077n
Ct66 t65 0 0.184162p
Rt69 t65 tm67 0.00486442
Lt69 tm67 t68 0.773077n
Ct69 t68 0 0.184162p
Rt72 t68 tm70 0.00486442
Lt72 tm70 t71 0.773077n
Ct72 t71 0 0.184162p
Rt75 t71 tm73 0.00486442
Lt75 tm73 t74 0.773077n
Ct75 t74 0 0.184162p
Rt78 t74 tm76 0.00486442
Lt78 tm76 t77 0.773077n
Ct78 t77 0 0.184162p
Rt81 t77 tm79 0.00486442
Lt81 tm79 t80 0.773077n
Ct81 t80 0 0.184162p
Rt84 t80 tm82 0.00486442
Lt84 tm82 t83 0.773077n
Ct84 t83 0 0.184162p
Rt87 t83 tm85 0.00486442
Lt87 tm85 t86 0.773077n
Ct87 t86 0 0.184162p
Rt90 t86 tm88 0.00486442
Lt90 tm88 t89 0.773077n
Ct90 t89 0 0.184162p
Rt93 t89 tm91 0.00486442
Lt93 tm91 t92 0.773077n
Ct93 t92 0 0.184162p
Rt96 t92 tm94 0.00486442
Lt96 tm94 t95 0.773077n
Ct96 t95 0 0.184162p
Rt99 t95 tm97 0.00486442
Lt99 tm97 t98 0.773077n
Ct99 t98 0 0.184162p
Rt102 t98 tm100 0.00486442
Lt102 tm100 t101 0.773077n
Ct102 t101 0 0.184162p
Rt105 t101 tm103 0.00486442
Lt105 tm103 t104 0.773077n
Ct105 t104 0 0.184162p
Rt108 t104 tm106 0.00486442
Lt108 tm106 t107 0.773077n
Ct108 t107 0 0.184162p
Rt111 t107 tm109 0.00486442
Lt111 tm109 t110 0.773077n
Ct111 t110 0 0.184162p
Rt114 t110 tm112 0.00486442
Lt114 tm112 t113 0.773077n
Ct114 t113 0 0.184162p
Rt117 t113 tm115 0.00486442
Lt117 tm115 t116 0.773077n
Ct117 t116 0 0.184162p
Rt120 t116 tm118 0.00486442
Lt120 tm118 t119 0.773077n
Ct120 t119 0 0.184162p
Rt123 t119 tm121 0.00486442
Lt123 tm121 t122 0.773077n
Ct123 t122 0 0.184162p
Rt126 t122 tm124 0.00486442
Lt126 tm124 t125 0.773077n
Ct126 t125 0 0.184162p
Rt129 t125 tm127 0.00486442
Lt129 tm127 t128 0.773077n
Ct129 t128 0 0.184162p
Rt132 t128 tm130 0.00486442
Lt132 tm130 t131 0.773077n
Ct132 t131 0 0.184162p
Rt135 t131 tm133 0.00486442
Lt135 tm133 t134 0.773077n
Ct135 t134 0 0.184162p
Rt138 t134 tm136 0.00486442
Lt138 tm136 t137 0.773077n
Ct138 t137 0 0.184162p
Rt141 t137 tm139 0.00486442
Lt141 tm139 t140 0.773077n
Ct141 t140 0 0.184162p
Rt144 t140 tm142 0.00486442
Lt144 tm142 t143 0.773077n
Ct144 t143 0 0.184162p
Rt146 t143 tm145 0.00486442
Lt146 tm145 v1 0.773077n
Ct146 v1 0 0.184162p
Rca149 v1 cra150 0.00245714
Rcb149 a0 crb151 0.00245714
Lca149 cra150 ca147 0.383583n
Lcb149 crb151 cb148 0.383583n
Kc149 Lca149 Lcb149 0.28295
Cca149 ca147 0 0.07843p
Ccb149 cb148 0 0.07843p
Ccm149 ca147 cb148 0.0205423p
Rca154 ca147 cra155 0.00245714
Rcb154 cb148 crb156 0.00245714
Lca154 cra155 ca152 0.383583n
Lcb154 crb156 cb153 0.383583n
Kc154 Lca154 Lcb154 0.28295
Cca154 ca152 0 0.07843p
Ccb154 cb153 0 0.07843p
Ccm154 ca152 cb153 0.0205423p
Rca159 ca152 cra160 0.00245714
Rcb159 cb153 crb161 0.00245714
Lca159 cra160 ca157 0.383583n
Lcb159 crb161 cb158 0.383583n
Kc159 Lca159 Lcb159 0.28295
Cca159 ca157 0 0.07843p
Ccb159 cb158 0 0.07843p
Ccm159 ca157 cb158 0.0205423p
Rca164 ca157 cra165 0.00245714
Rcb164 cb158 crb166 0.00245714
Lca164 cra165 ca162 0.383583n
Lcb164 crb166 cb163 0.383583n
Kc164 Lca164 Lcb164 0.28295
Cca164 ca162 0 0.07843p
Ccb164 cb163 0 0.07843p
Ccm164 ca162 cb163 0.0205423p
Rca169 ca162 cra170 0.00245714
Rcb169 cb163 crb171 0.00245714
Lca169 cra170 ca167 0.383583n
Lcb169 crb171 cb168 0.383583n
Kc169 Lca169 Lcb169 0.28295
Cca169 ca167 0 0.07843p
Ccb169 cb168 0 0.07843p
Ccm169 ca167 cb168 0.0205423p
Rca174 ca167 cra175 0.00245714
Rcb174 cb168 crb176 0.00245714
Lca174 cra175 ca172 0.383583n
Lcb174 crb176 cb173 0.383583n
Kc174 Lca174 Lcb174 0.28295
Cca174 ca172 0 0.07843p
Ccb174 cb173 0 0.07843p
Ccm174 ca172 cb173 0.0205423p
Rca179 ca172 cra180 0.00245714
Rcb179 cb173 crb181 0.00245714
Lca179 cra180 ca177 0.383583n
Lcb179 crb181 cb178 0.383583n
Kc179 Lca179 Lcb179 0.28295
Cca179 ca177 0 0.07843p
Ccb179 cb178 0 0.07843p
Ccm179 ca177 cb178 0.0205423p
Rca184 ca177 cra185 0.00245714
Rcb184 cb178 crb186 0.00245714
Lca184 cra185 ca182 0.383583n
Lcb184 crb186 cb183 0.383583n
Kc184 Lca184 Lcb184 0.28295
Cca184 ca182 0 0.07843p
Ccb184 cb183 0 0.07843p
Ccm184 ca182 cb183 0.0205423p
Rca189 ca182 cra190 0.00245714
Rcb189 cb183 crb191 0.00245714
Lca189 cra190 ca187 0.383583n
Lcb189 crb191 cb188 0.383583n
Kc189 Lca189 Lcb189 0.28295
Cca189 ca187 0 0.07843p
Ccb189 cb188 0 0.07843p
Ccm189 ca187 cb188 0.0205423p
Rca194 ca187 cra195 0.00245714
Rcb194 cb188 crb196 0.00245714
Lca194 cra195 ca192 0.383583n
Lcb194 crb196 cb193 0.383583n
Kc194 Lca194 Lcb194 0.28295
Cca194 ca192 0 0.07843p
Ccb194 cb193 0 0.07843p
Ccm194 ca192 cb193 0.0205423p
Rca199 ca192 cra200 0.00245714
Rcb199 cb193 crb201 0.00245714
Lca199 cra200 ca197 0.383583n
Lcb199 crb201 cb198 0.383583n
Kc199 Lca199 Lcb199 0.28295
Cca199 ca197 0 0.07843p
Ccb199 cb198 0 0.07843p
Ccm199 ca197 cb198 0.0205423p
Rca204 ca197 cra205 0.00245714
Rcb204 cb198 crb206 0.00245714
Lca204 cra205 ca202 0.383583n
Lcb204 crb206 cb203 0.383583n
Kc204 Lca204 Lcb204 0.28295
Cca204 ca202 0 0.07843p
Ccb204 cb203 0 0.07843p
Ccm204 ca202 cb203 0.0205423p
Rca209 ca202 cra210 0.00245714
Rcb209 cb203 crb211 0.00245714
Lca209 cra210 ca207 0.383583n
Lcb209 crb211 cb208 0.383583n
Kc209 Lca209 Lcb209 0.28295
Cca209 ca207 0 0.07843p
Ccb209 cb208 0 0.07843p
Ccm209 ca207 cb208 0.0205423p
Rca214 ca207 cra215 0.00245714
Rcb214 cb208 crb216 0.00245714
Lca214 cra215 ca212 0.383583n
Lcb214 crb216 cb213 0.383583n
Kc214 Lca214 Lcb214 0.28295
Cca214 ca212 0 0.07843p
Ccb214 cb213 0 0.07843p
Ccm214 ca212 cb213 0.0205423p
Rca219 ca212 cra220 0.00245714
Rcb219 cb213 crb221 0.00245714
Lca219 cra220 ca217 0.383583n
Lcb219 crb221 cb218 0.383583n
Kc219 Lca219 Lcb219 0.28295
Cca219 ca217 0 0.07843p
Ccb219 cb218 0 0.07843p
Ccm219 ca217 cb218 0.0205423p
Rca224 ca217 cra225 0.00245714
Rcb224 cb218 crb226 0.00245714
Lca224 cra225 ca222 0.383583n
Lcb224 crb226 cb223 0.383583n
Kc224 Lca224 Lcb224 0.28295
Cca224 ca222 0 0.07843p
Ccb224 cb223 0 0.07843p
Ccm224 ca222 cb223 0.0205423p
Rca229 ca222 cra230 0.00245714
Rcb229 cb223 crb231 0.00245714
Lca229 cra230 ca227 0.383583n
Lcb229 crb231 cb228 0.383583n
Kc229 Lca229 Lcb229 0.28295
Cca229 ca227 0 0.07843p
Ccb229 cb228 0 0.07843p
Ccm229 ca227 cb228 0.0205423p
Rca234 ca227 cra235 0.00245714
Rcb234 cb228 crb236 0.00245714
Lca234 cra235 ca232 0.383583n
Lcb234 crb236 cb233 0.383583n
Kc234 Lca234 Lcb234 0.28295
Cca234 ca232 0 0.07843p
Ccb234 cb233 0 0.07843p
Ccm234 ca232 cb233 0.0205423p
Rca239 ca232 cra240 0.00245714
Rcb239 cb233 crb241 0.00245714
Lca239 cra240 ca237 0.383583n
Lcb239 crb241 cb238 0.383583n
Kc239 Lca239 Lcb239 0.28295
Cca239 ca237 0 0.07843p
Ccb239 cb238 0 0.07843p
Ccm239 ca237 cb238 0.0205423p
Rca244 ca237 cra245 0.00245714
Rcb244 cb238 crb246 0.00245714
Lca244 cra245 ca242 0.383583n
Lcb244 crb246 cb243 0.383583n
Kc244 Lca244 Lcb244 0.28295
Cca244 ca242 0 0.07843p
Ccb244 cb243 0 0.07843p
Ccm244 ca242 cb243 0.0205423p
Rca249 ca242 cra250 0.00245714
Rcb249 cb243 crb251 0.00245714
Lca249 cra250 ca247 0.383583n
Lcb249 crb251 cb248 0.383583n
Kc249 Lca249 Lcb249 0.28295
Cca249 ca247 0 0.07843p
Ccb249 cb248 0 0.07843p
Ccm249 ca247 cb248 0.0205423p
Rca254 ca247 cra255 0.00245714
Rcb254 cb248 crb256 0.00245714
Lca254 cra255 ca252 0.383583n
Lcb254 crb256 cb253 0.383583n
Kc254 Lca254 Lcb254 0.28295
Cca254 ca252 0 0.07843p
Ccb254 cb253 0 0.07843p
Ccm254 ca252 cb253 0.0205423p
Rca259 ca252 cra260 0.00245714
Rcb259 cb253 crb261 0.00245714
Lca259 cra260 ca257 0.383583n
Lcb259 crb261 cb258 0.383583n
Kc259 Lca259 Lcb259 0.28295
Cca259 ca257 0 0.07843p
Ccb259 cb258 0 0.07843p
Ccm259 ca257 cb258 0.0205423p
Rca264 ca257 cra265 0.00245714
Rcb264 cb258 crb266 0.00245714
Lca264 cra265 ca262 0.383583n
Lcb264 crb266 cb263 0.383583n
Kc264 Lca264 Lcb264 0.28295
Cca264 ca262 0 0.07843p
Ccb264 cb263 0 0.07843p
Ccm264 ca262 cb263 0.0205423p
Rca269 ca262 cra270 0.00245714
Rcb269 cb263 crb271 0.00245714
Lca269 cra270 ca267 0.383583n
Lcb269 crb271 cb268 0.383583n
Kc269 Lca269 Lcb269 0.28295
Cca269 ca267 0 0.07843p
Ccb269 cb268 0 0.07843p
Ccm269 ca267 cb268 0.0205423p
Rca274 ca267 cra275 0.00245714
Rcb274 cb268 crb276 0.00245714
Lca274 cra275 ca272 0.383583n
Lcb274 crb276 cb273 0.383583n
Kc274 Lca274 Lcb274 0.28295
Cca274 ca272 0 0.07843p
Ccb274 cb273 0 0.07843p
Ccm274 ca272 cb273 0.0205423p
Rca279 ca272 cra280 0.00245714
Rcb279 cb273 crb281 0.00245714
Lca279 cra280 ca277 0.383583n
Lcb279 crb281 cb278 0.383583n
Kc279 Lca279 Lcb279 0.28295
Cca279 ca277 0 0.07843p
Ccb279 cb278 0 0.07843p
Ccm279 ca277 cb278 0.0205423p
Rca284 ca277 cra285 0.00245714
Rcb284 cb278 crb286 0.00245714
Lca284 cra285 ca282 0.383583n
Lcb284 crb286 cb283 0.383583n
Kc284 Lca284 Lcb284 0.28295
Cca284 ca282 0 0.07843p
Ccb284 cb283 0 0.07843p
Ccm284 ca282 cb283 0.0205423p
Rca289 ca282 cra290 0.00245714
Rcb289 cb283 crb291 0.00245714
Lca289 cra290 ca287 0.383583n
Lcb289 crb291 cb288 0.383583n
Kc289 Lca289 Lcb289 0.28295
Cca289 ca287 0 0.07843p
Ccb289 cb288 0 0.07843p
Ccm289 ca287 cb288 0.0205423p
Rca294 ca287 cra295 0.00245714
Rcb294 cb288 crb296 0.00245714
Lca294 cra295 ca292 0.383583n
Lcb294 crb296 cb293 0.383583n
Kc294 Lca294 Lcb294 0.28295
Cca294 ca292 0 0.07843p
Ccb294 cb293 0 0.07843p
Ccm294 ca292 cb293 0.0205423p
Rca299 ca292 cra300 0.00245714
Rcb299 cb293 crb301 0.00245714
Lca299 cra300 ca297 0.383583n
Lcb299 crb301 cb298 0.383583n
Kc299 Lca299 Lcb299 0.28295
Cca299 ca297 0 0.07843p
Ccb299 cb298 0 0.07843p
Ccm299 ca297 cb298 0.0205423p
Rca304 ca297 cra305 0.00245714
Rcb304 cb298 crb306 0.00245714
Lca304 cra305 ca302 0.383583n
Lcb304 crb306 cb303 0.383583n
Kc304 Lca304 Lcb304 0.28295
Cca304 ca302 0 0.07843p
Ccb304 cb303 0 0.07843p
Ccm304 ca302 cb303 0.0205423p
Rca309 ca302 cra310 0.00245714
Rcb309 cb303 crb311 0.00245714
Lca309 cra310 ca307 0.383583n
Lcb309 crb311 cb308 0.383583n
Kc309 Lca309 Lcb309 0.28295
Cca309 ca307 0 0.07843p
Ccb309 cb308 0 0.07843p
Ccm309 ca307 cb308 0.0205423p
Rca314 ca307 cra315 0.00245714
Rcb314 cb308 crb316 0.00245714
Lca314 cra315 ca312 0.383583n
Lcb314 crb316 cb313 0.383583n
Kc314 Lca314 Lcb314 0.28295
Cca314 ca312 0 0.07843p
Ccb314 cb313 0 0.07843p
Ccm314 ca312 cb313 0.0205423p
Rca319 ca312 cra320 0.00245714
Rcb319 cb313 crb321 0.00245714
Lca319 cra320 ca317 0.383583n
Lcb319 crb321 cb318 0.383583n
Kc319 Lca319 Lcb319 0.28295
Cca319 ca317 0 0.07843p
Ccb319 cb318 0 0.07843p
Ccm319 ca317 cb318 0.0205423p
Rca324 ca317 cra325 0.00245714
Rcb324 cb318 crb326 0.00245714
Lca324 cra325 ca322 0.383583n
Lcb324 crb326 cb323 0.383583n
Kc324 Lca324 Lcb324 0.28295
Cca324 ca322 0 0.07843p
Ccb324 cb323 0 0.07843p
Ccm324 ca322 cb323 0.0205423p
Rca329 ca322 cra330 0.00245714
Rcb329 cb323 crb331 0.00245714
Lca329 cra330 ca327 0.383583n
Lcb329 crb331 cb328 0.383583n
Kc329 Lca329 Lcb329 0.28295
Cca329 ca327 0 0.07843p
Ccb329 cb328 0 0.07843p
Ccm329 ca327 cb328 0.0205423p
Rca334 ca327 cra335 0.00245714
Rcb334 cb328 crb336 0.00245714
Lca334 cra335 ca332 0.383583n
Lcb334 crb336 cb333 0.383583n
Kc334 Lca334 Lcb334 0.28295
Cca334 ca332 0 0.07843p
Ccb334 cb333 0 0.07843p
Ccm334 ca332 cb333 0.0205423p
Rca339 ca332 cra340 0.00245714
Rcb339 cb333 crb341 0.00245714
Lca339 cra340 ca337 0.383583n
Lcb339 crb341 cb338 0.383583n
Kc339 Lca339 Lcb339 0.28295
Cca339 ca337 0 0.07843p
Ccb339 cb338 0 0.07843p
Ccm339 ca337 cb338 0.0205423p
Rca344 ca337 cra345 0.00245714
Rcb344 cb338 crb346 0.00245714
Lca344 cra345 ca342 0.383583n
Lcb344 crb346 cb343 0.383583n
Kc344 Lca344 Lcb344 0.28295
Cca344 ca342 0 0.07843p
Ccb344 cb343 0 0.07843p
Ccm344 ca342 cb343 0.0205423p
Rca349 ca342 cra350 0.00245714
Rcb349 cb343 crb351 0.00245714
Lca349 cra350 ca347 0.383583n
Lcb349 crb351 cb348 0.383583n
Kc349 Lca349 Lcb349 0.28295
Cca349 ca347 0 0.07843p
Ccb349 cb348 0 0.07843p
Ccm349 ca347 cb348 0.0205423p
Rca354 ca347 cra355 0.00245714
Rcb354 cb348 crb356 0.00245714
Lca354 cra355 ca352 0.383583n
Lcb354 crb356 cb353 0.383583n
Kc354 Lca354 Lcb354 0.28295
Cca354 ca352 0 0.07843p
Ccb354 cb353 0 0.07843p
Ccm354 ca352 cb353 0.0205423p
Rca359 ca352 cra360 0.00245714
Rcb359 cb353 crb361 0.00245714
Lca359 cra360 ca357 0.383583n
Lcb359 crb361 cb358 0.383583n
Kc359 Lca359 Lcb359 0.28295
Cca359 ca357 0 0.07843p
Ccb359 cb358 0 0.07843p
Ccm359 ca357 cb358 0.0205423p
Rca364 ca357 cra365 0.00245714
Rcb364 cb358 crb366 0.00245714
Lca364 cra365 ca362 0.383583n
Lcb364 crb366 cb363 0.383583n
Kc364 Lca364 Lcb364 0.28295
Cca364 ca362 0 0.07843p
Ccb364 cb363 0 0.07843p
Ccm364 ca362 cb363 0.0205423p
Rca369 ca362 cra370 0.00245714
Rcb369 cb363 crb371 0.00245714
Lca369 cra370 ca367 0.383583n
Lcb369 crb371 cb368 0.383583n
Kc369 Lca369 Lcb369 0.28295
Cca369 ca367 0 0.07843p
Ccb369 cb368 0 0.07843p
Ccm369 ca367 cb368 0.0205423p
Rca374 ca367 cra375 0.00245714
Rcb374 cb368 crb376 0.00245714
Lca374 cra375 ca372 0.383583n
Lcb374 crb376 cb373 0.383583n
Kc374 Lca374 Lcb374 0.28295
Cca374 ca372 0 0.07843p
Ccb374 cb373 0 0.07843p
Ccm374 ca372 cb373 0.0205423p
Rca379 ca372 cra380 0.00245714
Rcb379 cb373 crb381 0.00245714
Lca379 cra380 ca377 0.383583n
Lcb379 crb381 cb378 0.383583n
Kc379 Lca379 Lcb379 0.28295
Cca379 ca377 0 0.07843p
Ccb379 cb378 0 0.07843p
Ccm379 ca377 cb378 0.0205423p
Rca384 ca377 cra385 0.00245714
Rcb384 cb378 crb386 0.00245714
Lca384 cra385 ca382 0.383583n
Lcb384 crb386 cb383 0.383583n
Kc384 Lca384 Lcb384 0.28295
Cca384 ca382 0 0.07843p
Ccb384 cb383 0 0.07843p
Ccm384 ca382 cb383 0.0205423p
Rca389 ca382 cra390 0.00245714
Rcb389 cb383 crb391 0.00245714
Lca389 cra390 ca387 0.383583n
Lcb389 crb391 cb388 0.383583n
Kc389 Lca389 Lcb389 0.28295
Cca389 ca387 0 0.07843p
Ccb389 cb388 0 0.07843p
Ccm389 ca387 cb388 0.0205423p
Rca394 ca387 cra395 0.00245714
Rcb394 cb388 crb396 0.00245714
Lca394 cra395 ca392 0.383583n
Lcb394 crb396 cb393 0.383583n
Kc394 Lca394 Lcb394 0.28295
Cca394 ca392 0 0.07843p
Ccb394 cb393 0 0.07843p
Ccm394 ca392 cb393 0.0205423p
Rca399 ca392 cra400 0.00245714
Rcb399 cb393 crb401 0.00245714
Lca399 cra400 ca397 0.383583n
Lcb399 crb401 cb398 0.383583n
Kc399 Lca399 Lcb399 0.28295
Cca399 ca397 0 0.07843p
Ccb399 cb398 0 0.07843p
Ccm399 ca397 cb398 0.0205423p
Rca404 ca397 cra405 0.00245714
Rcb404 cb398 crb406 0.00245714
Lca404 cra405 ca402 0.383583n
Lcb404 crb406 cb403 0.383583n
Kc404 Lca404 Lcb404 0.28295
Cca404 ca402 0 0.07843p
Ccb404 cb403 0 0.07843p
Ccm404 ca402 cb403 0.0205423p
Rca409 ca402 cra410 0.00245714
Rcb409 cb403 crb411 0.00245714
Lca409 cra410 ca407 0.383583n
Lcb409 crb411 cb408 0.383583n
Kc409 Lca409 Lcb409 0.28295
Cca409 ca407 0 0.07843p
Ccb409 cb408 0 0.07843p
Ccm409 ca407 cb408 0.0205423p
Rca414 ca407 cra415 0.00245714
Rcb414 cb408 crb416 0.00245714
Lca414 cra415 ca412 0.383583n
Lcb414 crb416 cb413 0.383583n
Kc414 Lca414 Lcb414 0.28295
Cca414 ca412 0 0.07843p
Ccb414 cb413 0 0.07843p
Ccm414 ca412 cb413 0.0205423p
Rca419 ca412 cra420 0.00245714
Rcb419 cb413 crb421 0.00245714
Lca419 cra420 ca417 0.383583n
Lcb419 crb421 cb418 0.383583n
Kc419 Lca419 Lcb419 0.28295
Cca419 ca417 0 0.07843p
Ccb419 cb418 0 0.07843p
Ccm419 ca417 cb418 0.0205423p
Rca424 ca417 cra425 0.00245714
Rcb424 cb418 crb426 0.00245714
Lca424 cra425 ca422 0.383583n
Lcb424 crb426 cb423 0.383583n
Kc424 Lca424 Lcb424 0.28295
Cca424 ca422 0 0.07843p
Ccb424 cb423 0 0.07843p
Ccm424 ca422 cb423 0.0205423p
Rca429 ca422 cra430 0.00245714
Rcb429 cb423 crb431 0.00245714
Lca429 cra430 ca427 0.383583n
Lcb429 crb431 cb428 0.383583n
Kc429 Lca429 Lcb429 0.28295
Cca429 ca427 0 0.07843p
Ccb429 cb428 0 0.07843p
Ccm429 ca427 cb428 0.0205423p
Rca434 ca427 cra435 0.00245714
Rcb434 cb428 crb436 0.00245714
Lca434 cra435 ca432 0.383583n
Lcb434 crb436 cb433 0.383583n
Kc434 Lca434 Lcb434 0.28295
Cca434 ca432 0 0.07843p
Ccb434 cb433 0 0.07843p
Ccm434 ca432 cb433 0.0205423p
Rca439 ca432 cra440 0.00245714
Rcb439 cb433 crb441 0.00245714
Lca439 cra440 ca437 0.383583n
Lcb439 crb441 cb438 0.383583n
Kc439 Lca439 Lcb439 0.28295
Cca439 ca437 0 0.07843p
Ccb439 cb438 0 0.07843p
Ccm439 ca437 cb438 0.0205423p
Rca444 ca437 cra445 0.00245714
Rcb444 cb438 crb446 0.00245714
Lca444 cra445 ca442 0.383583n
Lcb444 crb446 cb443 0.383583n
Kc444 Lca444 Lcb444 0.28295
Cca444 ca442 0 0.07843p
Ccb444 cb443 0 0.07843p
Ccm444 ca442 cb443 0.0205423p
Rca449 ca442 cra450 0.00245714
Rcb449 cb443 crb451 0.00245714
Lca449 cra450 ca447 0.383583n
Lcb449 crb451 cb448 0.383583n
Kc449 Lca449 Lcb449 0.28295
Cca449 ca447 0 0.07843p
Ccb449 cb448 0 0.07843p
Ccm449 ca447 cb448 0.0205423p
Rca454 ca447 cra455 0.00245714
Rcb454 cb448 crb456 0.00245714
Lca454 cra455 ca452 0.383583n
Lcb454 crb456 cb453 0.383583n
Kc454 Lca454 Lcb454 0.28295
Cca454 ca452 0 0.07843p
Ccb454 cb453 0 0.07843p
Ccm454 ca452 cb453 0.0205423p
Rca459 ca452 cra460 0.00245714
Rcb459 cb453 crb461 0.00245714
Lca459 cra460 ca457 0.383583n
Lcb459 crb461 cb458 0.383583n
Kc459 Lca459 Lcb459 0.28295
Cca459 ca457 0 0.07843p
Ccb459 cb458 0 0.07843p
Ccm459 ca457 cb458 0.0205423p
Rca464 ca457 cra465 0.00245714
Rcb464 cb458 crb466 0.00245714
Lca464 cra465 ca462 0.383583n
Lcb464 crb466 cb463 0.383583n
Kc464 Lca464 Lcb464 0.28295
Cca464 ca462 0 0.07843p
Ccb464 cb463 0 0.07843p
Ccm464 ca462 cb463 0.0205423p
Rca469 ca462 cra470 0.00245714
Rcb469 cb463 crb471 0.00245714
Lca469 cra470 ca467 0.383583n
Lcb469 crb471 cb468 0.383583n
Kc469 Lca469 Lcb469 0.28295
Cca469 ca467 0 0.07843p
Ccb469 cb468 0 0.07843p
Ccm469 ca467 cb468 0.0205423p
Rca474 ca467 cra475 0.00245714
Rcb474 cb468 crb476 0.00245714
Lca474 cra475 ca472 0.383583n
Lcb474 crb476 cb473 0.383583n
Kc474 Lca474 Lcb474 0.28295
Cca474 ca472 0 0.07843p
Ccb474 cb473 0 0.07843p
Ccm474 ca472 cb473 0.0205423p
Rca479 ca472 cra480 0.00245714
Rcb479 cb473 crb481 0.00245714
Lca479 cra480 ca477 0.383583n
Lcb479 crb481 cb478 0.383583n
Kc479 Lca479 Lcb479 0.28295
Cca479 ca477 0 0.07843p
Ccb479 cb478 0 0.07843p
Ccm479 ca477 cb478 0.0205423p
Rca484 ca477 cra485 0.00245714
Rcb484 cb478 crb486 0.00245714
Lca484 cra485 ca482 0.383583n
Lcb484 crb486 cb483 0.383583n
Kc484 Lca484 Lcb484 0.28295
Cca484 ca482 0 0.07843p
Ccb484 cb483 0 0.07843p
Ccm484 ca482 cb483 0.0205423p
Rca489 ca482 cra490 0.00245714
Rcb489 cb483 crb491 0.00245714
Lca489 cra490 ca487 0.383583n
Lcb489 crb491 cb488 0.383583n
Kc489 Lca489 Lcb489 0.28295
Cca489 ca487 0 0.07843p
Ccb489 cb488 0 0.07843p
Ccm489 ca487 cb488 0.0205423p
Rca494 ca487 cra495 0.00245714
Rcb494 cb488 crb496 0.00245714
Lca494 cra495 ca492 0.383583n
Lcb494 crb496 cb493 0.383583n
Kc494 Lca494 Lcb494 0.28295
Cca494 ca492 0 0.07843p
Ccb494 cb493 0 0.07843p
Ccm494 ca492 cb493 0.0205423p
Rca499 ca492 cra500 0.00245714
Rcb499 cb493 crb501 0.00245714
Lca499 cra500 ca497 0.383583n
Lcb499 crb501 cb498 0.383583n
Kc499 Lca499 Lcb499 0.28295
Cca499 ca497 0 0.07843p
Ccb499 cb498 0 0.07843p
Ccm499 ca497 cb498 0.0205423p
Rca504 ca497 cra505 0.00245714
Rcb504 cb498 crb506 0.00245714
Lca504 cra505 ca502 0.383583n
Lcb504 crb506 cb503 0.383583n
Kc504 Lca504 Lcb504 0.28295
Cca504 ca502 0 0.07843p
Ccb504 cb503 0 0.07843p
Ccm504 ca502 cb503 0.0205423p
Rca509 ca502 cra510 0.00245714
Rcb509 cb503 crb511 0.00245714
Lca509 cra510 ca507 0.383583n
Lcb509 crb511 cb508 0.383583n
Kc509 Lca509 Lcb509 0.28295
Cca509 ca507 0 0.07843p
Ccb509 cb508 0 0.07843p
Ccm509 ca507 cb508 0.0205423p
Rca514 ca507 cra515 0.00245714
Rcb514 cb508 crb516 0.00245714
Lca514 cra515 ca512 0.383583n
Lcb514 crb516 cb513 0.383583n
Kc514 Lca514 Lcb514 0.28295
Cca514 ca512 0 0.07843p
Ccb514 cb513 0 0.07843p
Ccm514 ca512 cb513 0.0205423p
Rca519 ca512 cra520 0.00245714
Rcb519 cb513 crb521 0.00245714
Lca519 cra520 ca517 0.383583n
Lcb519 crb521 cb518 0.383583n
Kc519 Lca519 Lcb519 0.28295
Cca519 ca517 0 0.07843p
Ccb519 cb518 0 0.07843p
Ccm519 ca517 cb518 0.0205423p
Rca524 ca517 cra525 0.00245714
Rcb524 cb518 crb526 0.00245714
Lca524 cra525 ca522 0.383583n
Lcb524 crb526 cb523 0.383583n
Kc524 Lca524 Lcb524 0.28295
Cca524 ca522 0 0.07843p
Ccb524 cb523 0 0.07843p
Ccm524 ca522 cb523 0.0205423p
Rca529 ca522 cra530 0.00245714
Rcb529 cb523 crb531 0.00245714
Lca529 cra530 ca527 0.383583n
Lcb529 crb531 cb528 0.383583n
Kc529 Lca529 Lcb529 0.28295
Cca529 ca527 0 0.07843p
Ccb529 cb528 0 0.07843p
Ccm529 ca527 cb528 0.0205423p
Rca534 ca527 cra535 0.00245714
Rcb534 cb528 crb536 0.00245714
Lca534 cra535 ca532 0.383583n
Lcb534 crb536 cb533 0.383583n
Kc534 Lca534 Lcb534 0.28295
Cca534 ca532 0 0.07843p
Ccb534 cb533 0 0.07843p
Ccm534 ca532 cb533 0.0205423p
Rca539 ca532 cra540 0.00245714
Rcb539 cb533 crb541 0.00245714
Lca539 cra540 ca537 0.383583n
Lcb539 crb541 cb538 0.383583n
Kc539 Lca539 Lcb539 0.28295
Cca539 ca537 0 0.07843p
Ccb539 cb538 0 0.07843p
Ccm539 ca537 cb538 0.0205423p
Rca542 ca537 cra543 0.00245714
Rcb542 cb538 crb544 0.00245714
Lca542 cra543 v2 0.383583n
Lcb542 crb544 a1 0.383583n
Kc542 Lca542 Lcb542 0.28295
Cca542 v2 0 0.07843p
Ccb542 a1 0 0.07843p
Ccm542 v2 a1 0.0205423p
Rt547 v2 tm545 0.00486442
Lt547 tm545 t546 0.773077n
Ct547 t546 0 0.184162p
Rt550 t546 tm548 0.00486442
Lt550 tm548 t549 0.773077n
Ct550 t549 0 0.184162p
Rt553 t549 tm551 0.00486442
Lt553 tm551 t552 0.773077n
Ct553 t552 0 0.184162p
Rt556 t552 tm554 0.00486442
Lt556 tm554 t555 0.773077n
Ct556 t555 0 0.184162p
Rt559 t555 tm557 0.00486442
Lt559 tm557 t558 0.773077n
Ct559 t558 0 0.184162p
Rt562 t558 tm560 0.00486442
Lt562 tm560 t561 0.773077n
Ct562 t561 0 0.184162p
Rt565 t561 tm563 0.00486442
Lt565 tm563 t564 0.773077n
Ct565 t564 0 0.184162p
Rt568 t564 tm566 0.00486442
Lt568 tm566 t567 0.773077n
Ct568 t567 0 0.184162p
Rt571 t567 tm569 0.00486442
Lt571 tm569 t570 0.773077n
Ct571 t570 0 0.184162p
Rt574 t570 tm572 0.00486442
Lt574 tm572 t573 0.773077n
Ct574 t573 0 0.184162p
Rt577 t573 tm575 0.00486442
Lt577 tm575 t576 0.773077n
Ct577 t576 0 0.184162p
Rt580 t576 tm578 0.00486442
Lt580 tm578 t579 0.773077n
Ct580 t579 0 0.184162p
Rt583 t579 tm581 0.00486442
Lt583 tm581 t582 0.773077n
Ct583 t582 0 0.184162p
Rt586 t582 tm584 0.00486442
Lt586 tm584 t585 0.773077n
Ct586 t585 0 0.184162p
Rt589 t585 tm587 0.00486442
Lt589 tm587 t588 0.773077n
Ct589 t588 0 0.184162p
Rt592 t588 tm590 0.00486442
Lt592 tm590 t591 0.773077n
Ct592 t591 0 0.184162p
Rt595 t591 tm593 0.00486442
Lt595 tm593 t594 0.773077n
Ct595 t594 0 0.184162p
Rt598 t594 tm596 0.00486442
Lt598 tm596 t597 0.773077n
Ct598 t597 0 0.184162p
Rt601 t597 tm599 0.00486442
Lt601 tm599 t600 0.773077n
Ct601 t600 0 0.184162p
Rt604 t600 tm602 0.00486442
Lt604 tm602 t603 0.773077n
Ct604 t603 0 0.184162p
Rt607 t603 tm605 0.00486442
Lt607 tm605 t606 0.773077n
Ct607 t606 0 0.184162p
Rt610 t606 tm608 0.00486442
Lt610 tm608 t609 0.773077n
Ct610 t609 0 0.184162p
Rt613 t609 tm611 0.00486442
Lt613 tm611 t612 0.773077n
Ct613 t612 0 0.184162p
Rt616 t612 tm614 0.00486442
Lt616 tm614 t615 0.773077n
Ct616 t615 0 0.184162p
Rt619 t615 tm617 0.00486442
Lt619 tm617 t618 0.773077n
Ct619 t618 0 0.184162p
Rt622 t618 tm620 0.00486442
Lt622 tm620 t621 0.773077n
Ct622 t621 0 0.184162p
Rt625 t621 tm623 0.00486442
Lt625 tm623 t624 0.773077n
Ct625 t624 0 0.184162p
Rt628 t624 tm626 0.00486442
Lt628 tm626 t627 0.773077n
Ct628 t627 0 0.184162p
Rt631 t627 tm629 0.00486442
Lt631 tm629 t630 0.773077n
Ct631 t630 0 0.184162p
Rt634 t630 tm632 0.00486442
Lt634 tm632 t633 0.773077n
Ct634 t633 0 0.184162p
Rt637 t633 tm635 0.00486442
Lt637 tm635 t636 0.773077n
Ct637 t636 0 0.184162p
Rt640 t636 tm638 0.00486442
Lt640 tm638 t639 0.773077n
Ct640 t639 0 0.184162p
Rt643 t639 tm641 0.00486442
Lt643 tm641 t642 0.773077n
Ct643 t642 0 0.184162p
Rt646 t642 tm644 0.00486442
Lt646 tm644 t645 0.773077n
Ct646 t645 0 0.184162p
Rt649 t645 tm647 0.00486442
Lt649 tm647 t648 0.773077n
Ct649 t648 0 0.184162p
Rt652 t648 tm650 0.00486442
Lt652 tm650 t651 0.773077n
Ct652 t651 0 0.184162p
Rt655 t651 tm653 0.00486442
Lt655 tm653 t654 0.773077n
Ct655 t654 0 0.184162p
Rt658 t654 tm656 0.00486442
Lt658 tm656 t657 0.773077n
Ct658 t657 0 0.184162p
Rt661 t657 tm659 0.00486442
Lt661 tm659 t660 0.773077n
Ct661 t660 0 0.184162p
Rt664 t660 tm662 0.00486442
Lt664 tm662 t663 0.773077n
Ct664 t663 0 0.184162p
Rt667 t663 tm665 0.00486442
Lt667 tm665 t666 0.773077n
Ct667 t666 0 0.184162p
Rt670 t666 tm668 0.00486442
Lt670 tm668 t669 0.773077n
Ct670 t669 0 0.184162p
Rt673 t669 tm671 0.00486442
Lt673 tm671 t672 0.773077n
Ct673 t672 0 0.184162p
Rt676 t672 tm674 0.00486442
Lt676 tm674 t675 0.773077n
Ct676 t675 0 0.184162p
Rt679 t675 tm677 0.00486442
Lt679 tm677 t678 0.773077n
Ct679 t678 0 0.184162p
Rt682 t678 tm680 0.00486442
Lt682 tm680 t681 0.773077n
Ct682 t681 0 0.184162p
Rt685 t681 tm683 0.00486442
Lt685 tm683 t684 0.773077n
Ct685 t684 0 0.184162p
Rt688 t684 tm686 0.00486442
Lt688 tm686 t687 0.773077n
Ct688 t687 0 0.184162p
Rt690 t687 tm689 0.00486442
Lt690 tm689 din 0.773077n
Ct690 din 0 0.184162p
Cin din 0 5p
Cagg a1 0 30p
.options method=gear reltol=1e-3
.tran 0.05n 220n 0 0.1n
.control
set wr_singlescale
set wr_vecnames
set numdgt=7
run

wrdata /out/led_xtalk_3_victim_low_500.txt v(din) v(a1) v(v1)
.endc
.end
