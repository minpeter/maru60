* led_hop36_nom: SK6805 DOUT (assumed 100 ohm, 10 ns) -> 0.001 ohm in series -> routed hop -> DIN 5 pF
Vsrc src 0 PWL(0.0000n 0 100.0000n 0 110.0000n 4 400.0000n 4 410.0000n 0 1300.0000n 0 1310.0000n 4 2200.0000n 4 2210.0000n 0 2500.0000n 0 2510.0000n 4 2800.0000n 4 2810.0000n 0 3700.0000n 0 3710.0000n 4 4600.0000n 4 4610.0000n 0)
Rdrv src dout 100.0
Cdout dout 0 2p
Rt3 dout tm2 0.00245714
Lt3 tm2 p1 0.330178n
Ct3 p1 0 0.0612216p
Lv5 p1 v4 1.358n
Cv5 v4 0 0.4885p
Rt7 v4 tm6 0.00347492
Lt7 tm6 rs_a 0.466942n
Ct7 rs_a 0 0.0865805p
Rser rs_a rs_b 0.001
Cser rs_b 0 0.1p
Rt11 rs_b tm9 0.00594893
Lt11 tm9 t10 0.799387n
Ct11 t10 0 0.148222p
Rt14 t10 tm12 0.00594893
Lt14 tm12 t13 0.799387n
Ct14 t13 0 0.148222p
Rt17 t13 tm15 0.00594893
Lt17 tm15 t16 0.799387n
Ct17 t16 0 0.148222p
Rt20 t16 tm18 0.00594893
Lt20 tm18 t19 0.799387n
Ct20 t19 0 0.148222p
Rt22 t19 tm21 0.00594893
Lt22 tm21 p8 0.799387n
Ct22 p8 0 0.148222p
Lv24 p8 v23 1.358n
Cv24 v23 0 0.4885p
Rt28 v23 tm26 0.00564667
Lt28 tm26 t27 0.75877n
Ct28 t27 0 0.140691p
Rt31 t27 tm29 0.00564667
Lt31 tm29 t30 0.75877n
Ct31 t30 0 0.140691p
Rt34 t30 tm32 0.00564667
Lt34 tm32 t33 0.75877n
Ct34 t33 0 0.140691p
Rt37 t33 tm35 0.00564667
Lt37 tm35 t36 0.75877n
Ct37 t36 0 0.140691p
Rt40 t36 tm38 0.00564667
Lt40 tm38 t39 0.75877n
Ct40 t39 0 0.140691p
Rt43 t39 tm41 0.00564667
Lt43 tm41 t42 0.75877n
Ct43 t42 0 0.140691p
Rt45 t42 tm44 0.00564667
Lt45 tm44 p25 0.75877n
Ct45 p25 0 0.140691p
Lv47 p25 v46 1.358n
Cv47 v46 0 0.4885p
Rt51 v46 tm49 0.00591172
Lt51 tm49 t50 0.794387n
Ct51 t50 0 0.147295p
Rt54 t50 tm52 0.00591172
Lt54 tm52 t53 0.794387n
Ct54 t53 0 0.147295p
Rt56 t53 tm55 0.00591172
Lt56 tm55 p48 0.794387n
Ct56 p48 0 0.147295p
Lv58 p48 v57 1.358n
Cv58 v57 0 0.4885p
Rt62 v57 tm60 0.00603927
Lt62 tm60 t61 0.811526n
Ct62 t61 0 0.150473p
Rt65 t61 tm63 0.00603927
Lt65 tm63 t64 0.811526n
Ct65 t64 0 0.150473p
Rt68 t64 tm66 0.00603927
Lt68 tm66 t67 0.811526n
Ct68 t67 0 0.150473p
Rt71 t67 tm69 0.00603927
Lt71 tm69 t70 0.811526n
Ct71 t70 0 0.150473p
Rt74 t70 tm72 0.00603927
Lt74 tm72 t73 0.811526n
Ct74 t73 0 0.150473p
Rt77 t73 tm75 0.00603927
Lt77 tm75 t76 0.811526n
Ct77 t76 0 0.150473p
Rt80 t76 tm78 0.00603927
Lt80 tm78 t79 0.811526n
Ct80 t79 0 0.150473p
Rt82 t79 tm81 0.00603927
Lt82 tm81 p59 0.811526n
Ct82 p59 0 0.150473p
Lv84 p59 v83 1.358n
Cv84 v83 0 0.4885p
Rt88 v83 tm86 0.00651909
Lt88 tm86 t87 0.876002n
Ct88 t87 0 0.162428p
Rt91 t87 tm89 0.00651909
Lt91 tm89 t90 0.876002n
Ct91 t90 0 0.162428p
Rt93 t90 tm92 0.00651909
Lt93 tm92 p85 0.876002n
Ct93 p85 0 0.162428p
Lv95 p85 v94 1.358n
Cv95 v94 0 0.4885p
Rt99 v94 tm97 0.00561609
Lt99 tm97 t98 0.754661n
Ct99 t98 0 0.139929p
Rt102 t98 tm100 0.00561609
Lt102 tm100 t101 0.754661n
Ct102 t101 0 0.139929p
Rt105 t101 tm103 0.00561609
Lt105 tm103 t104 0.754661n
Ct105 t104 0 0.139929p
Rt108 t104 tm106 0.00561609
Lt108 tm106 t107 0.754661n
Ct108 t107 0 0.139929p
Rt110 t107 tm109 0.00561609
Lt110 tm109 p96 0.754661n
Ct110 p96 0 0.139929p
Lv112 p96 v111 1.358n
Cv112 v111 0 0.4885p
Rt116 v111 tm114 0.00505631
Lt116 tm114 t115 0.679441n
Ct116 t115 0 0.125982p
Rt119 t115 tm117 0.00505631
Lt119 tm117 t118 0.679441n
Ct119 t118 0 0.125982p
Rt122 t118 tm120 0.00505631
Lt122 tm120 t121 0.679441n
Ct122 t121 0 0.125982p
Rt124 t121 tm123 0.00505631
Lt124 tm123 p113 0.679441n
Ct124 p113 0 0.125982p
Lv126 p113 v125 1.358n
Cv126 v125 0 0.4885p
Rt128 v125 tm127 0.00351949
Lt128 tm127 din 0.472931n
Ct128 din 0 0.0876909p
Cin din 0 5p
.tran 0.1n 5000n 0 0.2n
.control
set wr_singlescale
set wr_vecnames
set numdgt=7
run

wrdata /out/led_hop36_nom.txt v(dout) v(din)
.endc
.end
