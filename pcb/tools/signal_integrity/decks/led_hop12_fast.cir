* led_hop12_fast: SK6805 DOUT (assumed 20 ohm, 2 ns) -> 100 ohm in series -> routed hop -> DIN 5 pF
Vsrc src 0 PWL(0.0000n 0 100.0000n 0 102.0000n 4 400.0000n 4 402.0000n 0 1300.0000n 0 1302.0000n 4 2200.0000n 4 2202.0000n 0 2500.0000n 0 2502.0000n 4 2800.0000n 4 2802.0000n 0 3700.0000n 0 3702.0000n 4 4600.0000n 4 4602.0000n 0)
Rdrv src dout 20.0
Cdout dout 0 2p
Rt3 dout tm1 0.003441
Lt3 tm1 t2 0.462384n
Ct3 t2 0 0.0857352p
Rt5 t2 tm4 0.003441
Lt5 tm4 rs_a 0.462384n
Ct5 rs_a 0 0.0857352p
Rser rs_a rs_b 100
Cser rs_b 0 0.1p
Rt9 rs_b tm7 0.00622672
Lt9 tm7 t8 0.836715n
Ct9 t8 0 0.155144p
Rt12 t8 tm10 0.00622672
Lt12 tm10 t11 0.836715n
Ct12 t11 0 0.155144p
Rt15 t11 tm13 0.00622672
Lt15 tm13 t14 0.836715n
Ct15 t14 0 0.155144p
Rt18 t14 tm16 0.00622672
Lt18 tm16 t17 0.836715n
Ct18 t17 0 0.155144p
Rt21 t17 tm19 0.00622672
Lt21 tm19 t20 0.836715n
Ct21 t20 0 0.155144p
Rt24 t20 tm22 0.00622672
Lt24 tm22 t23 0.836715n
Ct24 t23 0 0.155144p
Rt27 t23 tm25 0.00622672
Lt27 tm25 t26 0.836715n
Ct27 t26 0 0.155144p
Rt30 t26 tm28 0.00622672
Lt30 tm28 t29 0.836715n
Ct30 t29 0 0.155144p
Rt33 t29 tm31 0.00622672
Lt33 tm31 t32 0.836715n
Ct33 t32 0 0.155144p
Rt36 t32 tm34 0.00622672
Lt36 tm34 t35 0.836715n
Ct36 t35 0 0.155144p
Rt39 t35 tm37 0.00622672
Lt39 tm37 t38 0.836715n
Ct39 t38 0 0.155144p
Rt41 t38 tm40 0.00622672
Lt41 tm40 p6 0.836715n
Ct41 p6 0 0.155144p
Lv43 p6 v42 1.358n
Cv43 v42 0 0.4885p
Rt47 v42 tm45 0.00612073
Lt47 tm45 t46 0.822472n
Ct47 t46 0 0.152503p
Rt50 t46 tm48 0.00612073
Lt50 tm48 t49 0.822472n
Ct50 t49 0 0.152503p
Rt53 t49 tm51 0.00612073
Lt53 tm51 t52 0.822472n
Ct53 t52 0 0.152503p
Rt56 t52 tm54 0.00612073
Lt56 tm54 t55 0.822472n
Ct56 t55 0 0.152503p
Rt59 t55 tm57 0.00612073
Lt59 tm57 t58 0.822472n
Ct59 t58 0 0.152503p
Rt62 t58 tm60 0.00612073
Lt62 tm60 t61 0.822472n
Ct62 t61 0 0.152503p
Rt65 t61 tm63 0.00612073
Lt65 tm63 t64 0.822472n
Ct65 t64 0 0.152503p
Rt68 t64 tm66 0.00612073
Lt68 tm66 t67 0.822472n
Ct68 t67 0 0.152503p
Rt70 t67 tm69 0.00612073
Lt70 tm69 p44 0.822472n
Ct70 p44 0 0.152503p
Lv72 p44 v71 1.358n
Cv72 v71 0 0.4885p
Rt75 v71 tm74 0.00555988
Lt75 tm74 p73 0.747108n
Ct75 p73 0 0.138529p
Lv77 p73 v76 1.358n
Cv77 v76 0 0.4885p
Rt81 v76 tm79 0.00607563
Lt81 tm79 t80 0.816412n
Ct81 t80 0 0.151379p
Rt84 t80 tm82 0.00607563
Lt84 tm82 t83 0.816412n
Ct84 t83 0 0.151379p
Rt87 t83 tm85 0.00607563
Lt87 tm85 t86 0.816412n
Ct87 t86 0 0.151379p
Rt90 t86 tm88 0.00607563
Lt90 tm88 t89 0.816412n
Ct90 t89 0 0.151379p
Rt93 t89 tm91 0.00607563
Lt93 tm91 t92 0.816412n
Ct93 t92 0 0.151379p
Rt96 t92 tm94 0.00607563
Lt96 tm94 t95 0.816412n
Ct96 t95 0 0.151379p
Rt98 t95 tm97 0.00607563
Lt98 tm97 p78 0.816412n
Ct98 p78 0 0.151379p
Lv100 p78 v99 1.358n
Cv100 v99 0 0.4885p
Rt103 v99 tm101 0.00384711
Lt103 tm101 t102 0.516955n
Ct103 t102 0 0.0958538p
Rt105 t102 tm104 0.00384711
Lt105 tm104 din 0.516955n
Ct105 din 0 0.0958538p
Cin din 0 5p
.tran 0.1n 5000n 0 0.2n
.control
set wr_singlescale
set wr_vecnames
set numdgt=7
run

wrdata /out/led_hop12_fast.txt v(dout) v(din)
.endc
.end
