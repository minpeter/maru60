* led_xtalk_1_victim_high_500: matrix line beside a quiet LED data hop, 49 mm at 0.25 mm gap
Vq q 0 4.0
Rq q v0 500.0
Vagg a 0 PWL(0 0 20n 0 21n 3.3 120n 3.3 121n 0)
Ragg a a0 40
Rt3 v0 tm1 0.00489273
Lt3 tm1 t2 0.777577n
Ct3 t2 0 0.185234p
Rt6 t2 tm4 0.00489273
Lt6 tm4 t5 0.777577n
Ct6 t5 0 0.185234p
Rt9 t5 tm7 0.00489273
Lt9 tm7 t8 0.777577n
Ct9 t8 0 0.185234p
Rt12 t8 tm10 0.00489273
Lt12 tm10 t11 0.777577n
Ct12 t11 0 0.185234p
Rt15 t11 tm13 0.00489273
Lt15 tm13 t14 0.777577n
Ct15 t14 0 0.185234p
Rt18 t14 tm16 0.00489273
Lt18 tm16 t17 0.777577n
Ct18 t17 0 0.185234p
Rt21 t17 tm19 0.00489273
Lt21 tm19 t20 0.777577n
Ct21 t20 0 0.185234p
Rt24 t20 tm22 0.00489273
Lt24 tm22 t23 0.777577n
Ct24 t23 0 0.185234p
Rt27 t23 tm25 0.00489273
Lt27 tm25 t26 0.777577n
Ct27 t26 0 0.185234p
Rt30 t26 tm28 0.00489273
Lt30 tm28 t29 0.777577n
Ct30 t29 0 0.185234p
Rt33 t29 tm31 0.00489273
Lt33 tm31 t32 0.777577n
Ct33 t32 0 0.185234p
Rt36 t32 tm34 0.00489273
Lt36 tm34 t35 0.777577n
Ct36 t35 0 0.185234p
Rt39 t35 tm37 0.00489273
Lt39 tm37 t38 0.777577n
Ct39 t38 0 0.185234p
Rt42 t38 tm40 0.00489273
Lt42 tm40 t41 0.777577n
Ct42 t41 0 0.185234p
Rt45 t41 tm43 0.00489273
Lt45 tm43 t44 0.777577n
Ct45 t44 0 0.185234p
Rt48 t44 tm46 0.00489273
Lt48 tm46 t47 0.777577n
Ct48 t47 0 0.185234p
Rt51 t47 tm49 0.00489273
Lt51 tm49 t50 0.777577n
Ct51 t50 0 0.185234p
Rt54 t50 tm52 0.00489273
Lt54 tm52 t53 0.777577n
Ct54 t53 0 0.185234p
Rt57 t53 tm55 0.00489273
Lt57 tm55 t56 0.777577n
Ct57 t56 0 0.185234p
Rt60 t56 tm58 0.00489273
Lt60 tm58 t59 0.777577n
Ct60 t59 0 0.185234p
Rt63 t59 tm61 0.00489273
Lt63 tm61 t62 0.777577n
Ct63 t62 0 0.185234p
Rt66 t62 tm64 0.00489273
Lt66 tm64 t65 0.777577n
Ct66 t65 0 0.185234p
Rt69 t65 tm67 0.00489273
Lt69 tm67 t68 0.777577n
Ct69 t68 0 0.185234p
Rt72 t68 tm70 0.00489273
Lt72 tm70 t71 0.777577n
Ct72 t71 0 0.185234p
Rt75 t71 tm73 0.00489273
Lt75 tm73 t74 0.777577n
Ct75 t74 0 0.185234p
Rt78 t74 tm76 0.00489273
Lt78 tm76 t77 0.777577n
Ct78 t77 0 0.185234p
Rt81 t77 tm79 0.00489273
Lt81 tm79 t80 0.777577n
Ct81 t80 0 0.185234p
Rt84 t80 tm82 0.00489273
Lt84 tm82 t83 0.777577n
Ct84 t83 0 0.185234p
Rt87 t83 tm85 0.00489273
Lt87 tm85 t86 0.777577n
Ct87 t86 0 0.185234p
Rt90 t86 tm88 0.00489273
Lt90 tm88 t89 0.777577n
Ct90 t89 0 0.185234p
Rt93 t89 tm91 0.00489273
Lt93 tm91 t92 0.777577n
Ct93 t92 0 0.185234p
Rt96 t92 tm94 0.00489273
Lt96 tm94 t95 0.777577n
Ct96 t95 0 0.185234p
Rt99 t95 tm97 0.00489273
Lt99 tm97 t98 0.777577n
Ct99 t98 0 0.185234p
Rt102 t98 tm100 0.00489273
Lt102 tm100 t101 0.777577n
Ct102 t101 0 0.185234p
Rt105 t101 tm103 0.00489273
Lt105 tm103 t104 0.777577n
Ct105 t104 0 0.185234p
Rt108 t104 tm106 0.00489273
Lt108 tm106 t107 0.777577n
Ct108 t107 0 0.185234p
Rt111 t107 tm109 0.00489273
Lt111 tm109 t110 0.777577n
Ct111 t110 0 0.185234p
Rt114 t110 tm112 0.00489273
Lt114 tm112 t113 0.777577n
Ct114 t113 0 0.185234p
Rt117 t113 tm115 0.00489273
Lt117 tm115 t116 0.777577n
Ct117 t116 0 0.185234p
Rt120 t116 tm118 0.00489273
Lt120 tm118 t119 0.777577n
Ct120 t119 0 0.185234p
Rt123 t119 tm121 0.00489273
Lt123 tm121 t122 0.777577n
Ct123 t122 0 0.185234p
Rt126 t122 tm124 0.00489273
Lt126 tm124 t125 0.777577n
Ct126 t125 0 0.185234p
Rt129 t125 tm127 0.00489273
Lt129 tm127 t128 0.777577n
Ct129 t128 0 0.185234p
Rt132 t128 tm130 0.00489273
Lt132 tm130 t131 0.777577n
Ct132 t131 0 0.185234p
Rt135 t131 tm133 0.00489273
Lt135 tm133 t134 0.777577n
Ct135 t134 0 0.185234p
Rt138 t134 tm136 0.00489273
Lt138 tm136 t137 0.777577n
Ct138 t137 0 0.185234p
Rt141 t137 tm139 0.00489273
Lt141 tm139 t140 0.777577n
Ct141 t140 0 0.185234p
Rt144 t140 tm142 0.00489273
Lt144 tm142 t143 0.777577n
Ct144 t143 0 0.185234p
Rt147 t143 tm145 0.00489273
Lt147 tm145 t146 0.777577n
Ct147 t146 0 0.185234p
Rt150 t146 tm148 0.00489273
Lt150 tm148 t149 0.777577n
Ct150 t149 0 0.185234p
Rt153 t149 tm151 0.00489273
Lt153 tm151 t152 0.777577n
Ct153 t152 0 0.185234p
Rt156 t152 tm154 0.00489273
Lt156 tm154 t155 0.777577n
Ct156 t155 0 0.185234p
Rt159 t155 tm157 0.00489273
Lt159 tm157 t158 0.777577n
Ct159 t158 0 0.185234p
Rt162 t158 tm160 0.00489273
Lt162 tm160 t161 0.777577n
Ct162 t161 0 0.185234p
Rt165 t161 tm163 0.00489273
Lt165 tm163 t164 0.777577n
Ct165 t164 0 0.185234p
Rt168 t164 tm166 0.00489273
Lt168 tm166 t167 0.777577n
Ct168 t167 0 0.185234p
Rt170 t167 tm169 0.00489273
Lt170 tm169 v1 0.777577n
Ct170 v1 0 0.185234p
Rca173 v1 cra174 0.00245714
Rcb173 a0 crb175 0.00245714
Lca173 cra174 ca171 0.387966n
Lcb173 crb175 cb172 0.387966n
Kc173 Lca173 Lcb173 0.19250
Cca173 ca171 0 0.0836398p
Ccb173 cb172 0 0.0836398p
Ccm173 ca171 cb172 0.0111742p
Rca178 ca171 cra179 0.00245714
Rcb178 cb172 crb180 0.00245714
Lca178 cra179 ca176 0.387966n
Lcb178 crb180 cb177 0.387966n
Kc178 Lca178 Lcb178 0.19250
Cca178 ca176 0 0.0836398p
Ccb178 cb177 0 0.0836398p
Ccm178 ca176 cb177 0.0111742p
Rca183 ca176 cra184 0.00245714
Rcb183 cb177 crb185 0.00245714
Lca183 cra184 ca181 0.387966n
Lcb183 crb185 cb182 0.387966n
Kc183 Lca183 Lcb183 0.19250
Cca183 ca181 0 0.0836398p
Ccb183 cb182 0 0.0836398p
Ccm183 ca181 cb182 0.0111742p
Rca188 ca181 cra189 0.00245714
Rcb188 cb182 crb190 0.00245714
Lca188 cra189 ca186 0.387966n
Lcb188 crb190 cb187 0.387966n
Kc188 Lca188 Lcb188 0.19250
Cca188 ca186 0 0.0836398p
Ccb188 cb187 0 0.0836398p
Ccm188 ca186 cb187 0.0111742p
Rca193 ca186 cra194 0.00245714
Rcb193 cb187 crb195 0.00245714
Lca193 cra194 ca191 0.387966n
Lcb193 crb195 cb192 0.387966n
Kc193 Lca193 Lcb193 0.19250
Cca193 ca191 0 0.0836398p
Ccb193 cb192 0 0.0836398p
Ccm193 ca191 cb192 0.0111742p
Rca198 ca191 cra199 0.00245714
Rcb198 cb192 crb200 0.00245714
Lca198 cra199 ca196 0.387966n
Lcb198 crb200 cb197 0.387966n
Kc198 Lca198 Lcb198 0.19250
Cca198 ca196 0 0.0836398p
Ccb198 cb197 0 0.0836398p
Ccm198 ca196 cb197 0.0111742p
Rca203 ca196 cra204 0.00245714
Rcb203 cb197 crb205 0.00245714
Lca203 cra204 ca201 0.387966n
Lcb203 crb205 cb202 0.387966n
Kc203 Lca203 Lcb203 0.19250
Cca203 ca201 0 0.0836398p
Ccb203 cb202 0 0.0836398p
Ccm203 ca201 cb202 0.0111742p
Rca208 ca201 cra209 0.00245714
Rcb208 cb202 crb210 0.00245714
Lca208 cra209 ca206 0.387966n
Lcb208 crb210 cb207 0.387966n
Kc208 Lca208 Lcb208 0.19250
Cca208 ca206 0 0.0836398p
Ccb208 cb207 0 0.0836398p
Ccm208 ca206 cb207 0.0111742p
Rca213 ca206 cra214 0.00245714
Rcb213 cb207 crb215 0.00245714
Lca213 cra214 ca211 0.387966n
Lcb213 crb215 cb212 0.387966n
Kc213 Lca213 Lcb213 0.19250
Cca213 ca211 0 0.0836398p
Ccb213 cb212 0 0.0836398p
Ccm213 ca211 cb212 0.0111742p
Rca218 ca211 cra219 0.00245714
Rcb218 cb212 crb220 0.00245714
Lca218 cra219 ca216 0.387966n
Lcb218 crb220 cb217 0.387966n
Kc218 Lca218 Lcb218 0.19250
Cca218 ca216 0 0.0836398p
Ccb218 cb217 0 0.0836398p
Ccm218 ca216 cb217 0.0111742p
Rca223 ca216 cra224 0.00245714
Rcb223 cb217 crb225 0.00245714
Lca223 cra224 ca221 0.387966n
Lcb223 crb225 cb222 0.387966n
Kc223 Lca223 Lcb223 0.19250
Cca223 ca221 0 0.0836398p
Ccb223 cb222 0 0.0836398p
Ccm223 ca221 cb222 0.0111742p
Rca228 ca221 cra229 0.00245714
Rcb228 cb222 crb230 0.00245714
Lca228 cra229 ca226 0.387966n
Lcb228 crb230 cb227 0.387966n
Kc228 Lca228 Lcb228 0.19250
Cca228 ca226 0 0.0836398p
Ccb228 cb227 0 0.0836398p
Ccm228 ca226 cb227 0.0111742p
Rca233 ca226 cra234 0.00245714
Rcb233 cb227 crb235 0.00245714
Lca233 cra234 ca231 0.387966n
Lcb233 crb235 cb232 0.387966n
Kc233 Lca233 Lcb233 0.19250
Cca233 ca231 0 0.0836398p
Ccb233 cb232 0 0.0836398p
Ccm233 ca231 cb232 0.0111742p
Rca238 ca231 cra239 0.00245714
Rcb238 cb232 crb240 0.00245714
Lca238 cra239 ca236 0.387966n
Lcb238 crb240 cb237 0.387966n
Kc238 Lca238 Lcb238 0.19250
Cca238 ca236 0 0.0836398p
Ccb238 cb237 0 0.0836398p
Ccm238 ca236 cb237 0.0111742p
Rca243 ca236 cra244 0.00245714
Rcb243 cb237 crb245 0.00245714
Lca243 cra244 ca241 0.387966n
Lcb243 crb245 cb242 0.387966n
Kc243 Lca243 Lcb243 0.19250
Cca243 ca241 0 0.0836398p
Ccb243 cb242 0 0.0836398p
Ccm243 ca241 cb242 0.0111742p
Rca248 ca241 cra249 0.00245714
Rcb248 cb242 crb250 0.00245714
Lca248 cra249 ca246 0.387966n
Lcb248 crb250 cb247 0.387966n
Kc248 Lca248 Lcb248 0.19250
Cca248 ca246 0 0.0836398p
Ccb248 cb247 0 0.0836398p
Ccm248 ca246 cb247 0.0111742p
Rca253 ca246 cra254 0.00245714
Rcb253 cb247 crb255 0.00245714
Lca253 cra254 ca251 0.387966n
Lcb253 crb255 cb252 0.387966n
Kc253 Lca253 Lcb253 0.19250
Cca253 ca251 0 0.0836398p
Ccb253 cb252 0 0.0836398p
Ccm253 ca251 cb252 0.0111742p
Rca258 ca251 cra259 0.00245714
Rcb258 cb252 crb260 0.00245714
Lca258 cra259 ca256 0.387966n
Lcb258 crb260 cb257 0.387966n
Kc258 Lca258 Lcb258 0.19250
Cca258 ca256 0 0.0836398p
Ccb258 cb257 0 0.0836398p
Ccm258 ca256 cb257 0.0111742p
Rca263 ca256 cra264 0.00245714
Rcb263 cb257 crb265 0.00245714
Lca263 cra264 ca261 0.387966n
Lcb263 crb265 cb262 0.387966n
Kc263 Lca263 Lcb263 0.19250
Cca263 ca261 0 0.0836398p
Ccb263 cb262 0 0.0836398p
Ccm263 ca261 cb262 0.0111742p
Rca268 ca261 cra269 0.00245714
Rcb268 cb262 crb270 0.00245714
Lca268 cra269 ca266 0.387966n
Lcb268 crb270 cb267 0.387966n
Kc268 Lca268 Lcb268 0.19250
Cca268 ca266 0 0.0836398p
Ccb268 cb267 0 0.0836398p
Ccm268 ca266 cb267 0.0111742p
Rca273 ca266 cra274 0.00245714
Rcb273 cb267 crb275 0.00245714
Lca273 cra274 ca271 0.387966n
Lcb273 crb275 cb272 0.387966n
Kc273 Lca273 Lcb273 0.19250
Cca273 ca271 0 0.0836398p
Ccb273 cb272 0 0.0836398p
Ccm273 ca271 cb272 0.0111742p
Rca278 ca271 cra279 0.00245714
Rcb278 cb272 crb280 0.00245714
Lca278 cra279 ca276 0.387966n
Lcb278 crb280 cb277 0.387966n
Kc278 Lca278 Lcb278 0.19250
Cca278 ca276 0 0.0836398p
Ccb278 cb277 0 0.0836398p
Ccm278 ca276 cb277 0.0111742p
Rca283 ca276 cra284 0.00245714
Rcb283 cb277 crb285 0.00245714
Lca283 cra284 ca281 0.387966n
Lcb283 crb285 cb282 0.387966n
Kc283 Lca283 Lcb283 0.19250
Cca283 ca281 0 0.0836398p
Ccb283 cb282 0 0.0836398p
Ccm283 ca281 cb282 0.0111742p
Rca288 ca281 cra289 0.00245714
Rcb288 cb282 crb290 0.00245714
Lca288 cra289 ca286 0.387966n
Lcb288 crb290 cb287 0.387966n
Kc288 Lca288 Lcb288 0.19250
Cca288 ca286 0 0.0836398p
Ccb288 cb287 0 0.0836398p
Ccm288 ca286 cb287 0.0111742p
Rca293 ca286 cra294 0.00245714
Rcb293 cb287 crb295 0.00245714
Lca293 cra294 ca291 0.387966n
Lcb293 crb295 cb292 0.387966n
Kc293 Lca293 Lcb293 0.19250
Cca293 ca291 0 0.0836398p
Ccb293 cb292 0 0.0836398p
Ccm293 ca291 cb292 0.0111742p
Rca298 ca291 cra299 0.00245714
Rcb298 cb292 crb300 0.00245714
Lca298 cra299 ca296 0.387966n
Lcb298 crb300 cb297 0.387966n
Kc298 Lca298 Lcb298 0.19250
Cca298 ca296 0 0.0836398p
Ccb298 cb297 0 0.0836398p
Ccm298 ca296 cb297 0.0111742p
Rca303 ca296 cra304 0.00245714
Rcb303 cb297 crb305 0.00245714
Lca303 cra304 ca301 0.387966n
Lcb303 crb305 cb302 0.387966n
Kc303 Lca303 Lcb303 0.19250
Cca303 ca301 0 0.0836398p
Ccb303 cb302 0 0.0836398p
Ccm303 ca301 cb302 0.0111742p
Rca308 ca301 cra309 0.00245714
Rcb308 cb302 crb310 0.00245714
Lca308 cra309 ca306 0.387966n
Lcb308 crb310 cb307 0.387966n
Kc308 Lca308 Lcb308 0.19250
Cca308 ca306 0 0.0836398p
Ccb308 cb307 0 0.0836398p
Ccm308 ca306 cb307 0.0111742p
Rca313 ca306 cra314 0.00245714
Rcb313 cb307 crb315 0.00245714
Lca313 cra314 ca311 0.387966n
Lcb313 crb315 cb312 0.387966n
Kc313 Lca313 Lcb313 0.19250
Cca313 ca311 0 0.0836398p
Ccb313 cb312 0 0.0836398p
Ccm313 ca311 cb312 0.0111742p
Rca318 ca311 cra319 0.00245714
Rcb318 cb312 crb320 0.00245714
Lca318 cra319 ca316 0.387966n
Lcb318 crb320 cb317 0.387966n
Kc318 Lca318 Lcb318 0.19250
Cca318 ca316 0 0.0836398p
Ccb318 cb317 0 0.0836398p
Ccm318 ca316 cb317 0.0111742p
Rca323 ca316 cra324 0.00245714
Rcb323 cb317 crb325 0.00245714
Lca323 cra324 ca321 0.387966n
Lcb323 crb325 cb322 0.387966n
Kc323 Lca323 Lcb323 0.19250
Cca323 ca321 0 0.0836398p
Ccb323 cb322 0 0.0836398p
Ccm323 ca321 cb322 0.0111742p
Rca328 ca321 cra329 0.00245714
Rcb328 cb322 crb330 0.00245714
Lca328 cra329 ca326 0.387966n
Lcb328 crb330 cb327 0.387966n
Kc328 Lca328 Lcb328 0.19250
Cca328 ca326 0 0.0836398p
Ccb328 cb327 0 0.0836398p
Ccm328 ca326 cb327 0.0111742p
Rca333 ca326 cra334 0.00245714
Rcb333 cb327 crb335 0.00245714
Lca333 cra334 ca331 0.387966n
Lcb333 crb335 cb332 0.387966n
Kc333 Lca333 Lcb333 0.19250
Cca333 ca331 0 0.0836398p
Ccb333 cb332 0 0.0836398p
Ccm333 ca331 cb332 0.0111742p
Rca338 ca331 cra339 0.00245714
Rcb338 cb332 crb340 0.00245714
Lca338 cra339 ca336 0.387966n
Lcb338 crb340 cb337 0.387966n
Kc338 Lca338 Lcb338 0.19250
Cca338 ca336 0 0.0836398p
Ccb338 cb337 0 0.0836398p
Ccm338 ca336 cb337 0.0111742p
Rca343 ca336 cra344 0.00245714
Rcb343 cb337 crb345 0.00245714
Lca343 cra344 ca341 0.387966n
Lcb343 crb345 cb342 0.387966n
Kc343 Lca343 Lcb343 0.19250
Cca343 ca341 0 0.0836398p
Ccb343 cb342 0 0.0836398p
Ccm343 ca341 cb342 0.0111742p
Rca348 ca341 cra349 0.00245714
Rcb348 cb342 crb350 0.00245714
Lca348 cra349 ca346 0.387966n
Lcb348 crb350 cb347 0.387966n
Kc348 Lca348 Lcb348 0.19250
Cca348 ca346 0 0.0836398p
Ccb348 cb347 0 0.0836398p
Ccm348 ca346 cb347 0.0111742p
Rca353 ca346 cra354 0.00245714
Rcb353 cb347 crb355 0.00245714
Lca353 cra354 ca351 0.387966n
Lcb353 crb355 cb352 0.387966n
Kc353 Lca353 Lcb353 0.19250
Cca353 ca351 0 0.0836398p
Ccb353 cb352 0 0.0836398p
Ccm353 ca351 cb352 0.0111742p
Rca358 ca351 cra359 0.00245714
Rcb358 cb352 crb360 0.00245714
Lca358 cra359 ca356 0.387966n
Lcb358 crb360 cb357 0.387966n
Kc358 Lca358 Lcb358 0.19250
Cca358 ca356 0 0.0836398p
Ccb358 cb357 0 0.0836398p
Ccm358 ca356 cb357 0.0111742p
Rca363 ca356 cra364 0.00245714
Rcb363 cb357 crb365 0.00245714
Lca363 cra364 ca361 0.387966n
Lcb363 crb365 cb362 0.387966n
Kc363 Lca363 Lcb363 0.19250
Cca363 ca361 0 0.0836398p
Ccb363 cb362 0 0.0836398p
Ccm363 ca361 cb362 0.0111742p
Rca368 ca361 cra369 0.00245714
Rcb368 cb362 crb370 0.00245714
Lca368 cra369 ca366 0.387966n
Lcb368 crb370 cb367 0.387966n
Kc368 Lca368 Lcb368 0.19250
Cca368 ca366 0 0.0836398p
Ccb368 cb367 0 0.0836398p
Ccm368 ca366 cb367 0.0111742p
Rca373 ca366 cra374 0.00245714
Rcb373 cb367 crb375 0.00245714
Lca373 cra374 ca371 0.387966n
Lcb373 crb375 cb372 0.387966n
Kc373 Lca373 Lcb373 0.19250
Cca373 ca371 0 0.0836398p
Ccb373 cb372 0 0.0836398p
Ccm373 ca371 cb372 0.0111742p
Rca378 ca371 cra379 0.00245714
Rcb378 cb372 crb380 0.00245714
Lca378 cra379 ca376 0.387966n
Lcb378 crb380 cb377 0.387966n
Kc378 Lca378 Lcb378 0.19250
Cca378 ca376 0 0.0836398p
Ccb378 cb377 0 0.0836398p
Ccm378 ca376 cb377 0.0111742p
Rca383 ca376 cra384 0.00245714
Rcb383 cb377 crb385 0.00245714
Lca383 cra384 ca381 0.387966n
Lcb383 crb385 cb382 0.387966n
Kc383 Lca383 Lcb383 0.19250
Cca383 ca381 0 0.0836398p
Ccb383 cb382 0 0.0836398p
Ccm383 ca381 cb382 0.0111742p
Rca388 ca381 cra389 0.00245714
Rcb388 cb382 crb390 0.00245714
Lca388 cra389 ca386 0.387966n
Lcb388 crb390 cb387 0.387966n
Kc388 Lca388 Lcb388 0.19250
Cca388 ca386 0 0.0836398p
Ccb388 cb387 0 0.0836398p
Ccm388 ca386 cb387 0.0111742p
Rca393 ca386 cra394 0.00245714
Rcb393 cb387 crb395 0.00245714
Lca393 cra394 ca391 0.387966n
Lcb393 crb395 cb392 0.387966n
Kc393 Lca393 Lcb393 0.19250
Cca393 ca391 0 0.0836398p
Ccb393 cb392 0 0.0836398p
Ccm393 ca391 cb392 0.0111742p
Rca398 ca391 cra399 0.00245714
Rcb398 cb392 crb400 0.00245714
Lca398 cra399 ca396 0.387966n
Lcb398 crb400 cb397 0.387966n
Kc398 Lca398 Lcb398 0.19250
Cca398 ca396 0 0.0836398p
Ccb398 cb397 0 0.0836398p
Ccm398 ca396 cb397 0.0111742p
Rca403 ca396 cra404 0.00245714
Rcb403 cb397 crb405 0.00245714
Lca403 cra404 ca401 0.387966n
Lcb403 crb405 cb402 0.387966n
Kc403 Lca403 Lcb403 0.19250
Cca403 ca401 0 0.0836398p
Ccb403 cb402 0 0.0836398p
Ccm403 ca401 cb402 0.0111742p
Rca408 ca401 cra409 0.00245714
Rcb408 cb402 crb410 0.00245714
Lca408 cra409 ca406 0.387966n
Lcb408 crb410 cb407 0.387966n
Kc408 Lca408 Lcb408 0.19250
Cca408 ca406 0 0.0836398p
Ccb408 cb407 0 0.0836398p
Ccm408 ca406 cb407 0.0111742p
Rca411 ca406 cra412 0.00245714
Rcb411 cb407 crb413 0.00245714
Lca411 cra412 v2 0.387966n
Lcb411 crb413 a1 0.387966n
Kc411 Lca411 Lcb411 0.19250
Cca411 v2 0 0.0836398p
Ccb411 a1 0 0.0836398p
Ccm411 v2 a1 0.0111742p
Rt416 v2 tm414 0.00489273
Lt416 tm414 t415 0.777577n
Ct416 t415 0 0.185234p
Rt419 t415 tm417 0.00489273
Lt419 tm417 t418 0.777577n
Ct419 t418 0 0.185234p
Rt422 t418 tm420 0.00489273
Lt422 tm420 t421 0.777577n
Ct422 t421 0 0.185234p
Rt425 t421 tm423 0.00489273
Lt425 tm423 t424 0.777577n
Ct425 t424 0 0.185234p
Rt428 t424 tm426 0.00489273
Lt428 tm426 t427 0.777577n
Ct428 t427 0 0.185234p
Rt431 t427 tm429 0.00489273
Lt431 tm429 t430 0.777577n
Ct431 t430 0 0.185234p
Rt434 t430 tm432 0.00489273
Lt434 tm432 t433 0.777577n
Ct434 t433 0 0.185234p
Rt437 t433 tm435 0.00489273
Lt437 tm435 t436 0.777577n
Ct437 t436 0 0.185234p
Rt440 t436 tm438 0.00489273
Lt440 tm438 t439 0.777577n
Ct440 t439 0 0.185234p
Rt443 t439 tm441 0.00489273
Lt443 tm441 t442 0.777577n
Ct443 t442 0 0.185234p
Rt446 t442 tm444 0.00489273
Lt446 tm444 t445 0.777577n
Ct446 t445 0 0.185234p
Rt449 t445 tm447 0.00489273
Lt449 tm447 t448 0.777577n
Ct449 t448 0 0.185234p
Rt452 t448 tm450 0.00489273
Lt452 tm450 t451 0.777577n
Ct452 t451 0 0.185234p
Rt455 t451 tm453 0.00489273
Lt455 tm453 t454 0.777577n
Ct455 t454 0 0.185234p
Rt458 t454 tm456 0.00489273
Lt458 tm456 t457 0.777577n
Ct458 t457 0 0.185234p
Rt461 t457 tm459 0.00489273
Lt461 tm459 t460 0.777577n
Ct461 t460 0 0.185234p
Rt464 t460 tm462 0.00489273
Lt464 tm462 t463 0.777577n
Ct464 t463 0 0.185234p
Rt467 t463 tm465 0.00489273
Lt467 tm465 t466 0.777577n
Ct467 t466 0 0.185234p
Rt470 t466 tm468 0.00489273
Lt470 tm468 t469 0.777577n
Ct470 t469 0 0.185234p
Rt473 t469 tm471 0.00489273
Lt473 tm471 t472 0.777577n
Ct473 t472 0 0.185234p
Rt476 t472 tm474 0.00489273
Lt476 tm474 t475 0.777577n
Ct476 t475 0 0.185234p
Rt479 t475 tm477 0.00489273
Lt479 tm477 t478 0.777577n
Ct479 t478 0 0.185234p
Rt482 t478 tm480 0.00489273
Lt482 tm480 t481 0.777577n
Ct482 t481 0 0.185234p
Rt485 t481 tm483 0.00489273
Lt485 tm483 t484 0.777577n
Ct485 t484 0 0.185234p
Rt488 t484 tm486 0.00489273
Lt488 tm486 t487 0.777577n
Ct488 t487 0 0.185234p
Rt491 t487 tm489 0.00489273
Lt491 tm489 t490 0.777577n
Ct491 t490 0 0.185234p
Rt494 t490 tm492 0.00489273
Lt494 tm492 t493 0.777577n
Ct494 t493 0 0.185234p
Rt497 t493 tm495 0.00489273
Lt497 tm495 t496 0.777577n
Ct497 t496 0 0.185234p
Rt500 t496 tm498 0.00489273
Lt500 tm498 t499 0.777577n
Ct500 t499 0 0.185234p
Rt503 t499 tm501 0.00489273
Lt503 tm501 t502 0.777577n
Ct503 t502 0 0.185234p
Rt506 t502 tm504 0.00489273
Lt506 tm504 t505 0.777577n
Ct506 t505 0 0.185234p
Rt509 t505 tm507 0.00489273
Lt509 tm507 t508 0.777577n
Ct509 t508 0 0.185234p
Rt512 t508 tm510 0.00489273
Lt512 tm510 t511 0.777577n
Ct512 t511 0 0.185234p
Rt515 t511 tm513 0.00489273
Lt515 tm513 t514 0.777577n
Ct515 t514 0 0.185234p
Rt518 t514 tm516 0.00489273
Lt518 tm516 t517 0.777577n
Ct518 t517 0 0.185234p
Rt521 t517 tm519 0.00489273
Lt521 tm519 t520 0.777577n
Ct521 t520 0 0.185234p
Rt524 t520 tm522 0.00489273
Lt524 tm522 t523 0.777577n
Ct524 t523 0 0.185234p
Rt527 t523 tm525 0.00489273
Lt527 tm525 t526 0.777577n
Ct527 t526 0 0.185234p
Rt530 t526 tm528 0.00489273
Lt530 tm528 t529 0.777577n
Ct530 t529 0 0.185234p
Rt533 t529 tm531 0.00489273
Lt533 tm531 t532 0.777577n
Ct533 t532 0 0.185234p
Rt536 t532 tm534 0.00489273
Lt536 tm534 t535 0.777577n
Ct536 t535 0 0.185234p
Rt539 t535 tm537 0.00489273
Lt539 tm537 t538 0.777577n
Ct539 t538 0 0.185234p
Rt542 t538 tm540 0.00489273
Lt542 tm540 t541 0.777577n
Ct542 t541 0 0.185234p
Rt545 t541 tm543 0.00489273
Lt545 tm543 t544 0.777577n
Ct545 t544 0 0.185234p
Rt548 t544 tm546 0.00489273
Lt548 tm546 t547 0.777577n
Ct548 t547 0 0.185234p
Rt551 t547 tm549 0.00489273
Lt551 tm549 t550 0.777577n
Ct551 t550 0 0.185234p
Rt554 t550 tm552 0.00489273
Lt554 tm552 t553 0.777577n
Ct554 t553 0 0.185234p
Rt557 t553 tm555 0.00489273
Lt557 tm555 t556 0.777577n
Ct557 t556 0 0.185234p
Rt560 t556 tm558 0.00489273
Lt560 tm558 t559 0.777577n
Ct560 t559 0 0.185234p
Rt563 t559 tm561 0.00489273
Lt563 tm561 t562 0.777577n
Ct563 t562 0 0.185234p
Rt566 t562 tm564 0.00489273
Lt566 tm564 t565 0.777577n
Ct566 t565 0 0.185234p
Rt569 t565 tm567 0.00489273
Lt569 tm567 t568 0.777577n
Ct569 t568 0 0.185234p
Rt572 t568 tm570 0.00489273
Lt572 tm570 t571 0.777577n
Ct572 t571 0 0.185234p
Rt575 t571 tm573 0.00489273
Lt575 tm573 t574 0.777577n
Ct575 t574 0 0.185234p
Rt578 t574 tm576 0.00489273
Lt578 tm576 t577 0.777577n
Ct578 t577 0 0.185234p
Rt581 t577 tm579 0.00489273
Lt581 tm579 t580 0.777577n
Ct581 t580 0 0.185234p
Rt583 t580 tm582 0.00489273
Lt583 tm582 din 0.777577n
Ct583 din 0 0.185234p
Cin din 0 5p
Cagg a1 0 30p
.options method=gear reltol=1e-3
.tran 0.05n 220n 0 0.1n
.control
set wr_singlescale
set wr_vecnames
set numdgt=7
run

wrdata /out/led_xtalk_1_victim_high_500.txt v(din) v(a1) v(v1)
.endc
.end
