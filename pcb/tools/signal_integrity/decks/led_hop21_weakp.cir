* led_hop21_weakp: SK6805 DOUT (assumed 1000 ohm, 30 ns) -> 100 ohm in series -> routed hop -> DIN 15 pF
Vsrc src 0 PWL(0.0000n 0 100.0000n 0 130.0000n 4 400.0000n 4 430.0000n 0 1300.0000n 0 1330.0000n 4 2200.0000n 4 2230.0000n 0 2500.0000n 0 2530.0000n 4 2800.0000n 4 2830.0000n 0 3700.0000n 0 3730.0000n 4 4600.0000n 4 4630.0000n 0)
Rdrv src dout 1000.0
Cdout dout 0 2p
Rs3 dout sm2 0.000749429
Ls3 sm2 stubend1 0.119103n
Cs3 stubend1 0 0.0283726p
Cs4 stubend1 0 0.15p
Rt7 dout tm6 0.00208495
Lt7 tm6 p5 0.331351n
Ct7 p5 0 0.0789342p
Rt11 p5 tm9 0.00393143
Lt11 tm9 t10 0.624802n
Ct11 t10 0 0.14884p
Rt14 t10 tm12 0.00393143
Lt14 tm12 t13 0.624802n
Ct14 t13 0 0.14884p
Rt16 t13 tm15 0.00393143
Lt16 tm15 p8 0.624802n
Ct16 p8 0 0.14884p
Rt19 p8 tm18 0.00312743
Lt19 tm18 p17 0.497027n
Ct19 p17 0 0.118401p
Rt23 p17 tm21 0.00344
Lt23 tm21 t22 0.546702n
Ct23 t22 0 0.130235p
Rt26 t22 tm24 0.00344
Lt26 tm24 t25 0.546702n
Ct26 t25 0 0.130235p
Rt28 t25 tm27 0.00344
Lt28 tm27 p20 0.546702n
Ct28 p20 0 0.130235p
Rt31 p20 tm30 6.08112e-05
Lt31 tm30 p29 0.00966441n
Ct31 p29 0 0.00230225p
Rt35 p29 tm33 0.00294066
Lt35 tm33 t34 0.467343n
Ct35 t34 0 0.11133p
Rt37 t34 tm36 0.00294066
Lt37 tm36 p32 0.467343n
Ct37 p32 0 0.11133p
Rt40 p32 tm39 0.000122857
Lt40 tm39 p38 0.0195251n
Ct40 p38 0 0.00465124p
Rt43 p38 tm42 0.00295369
Lt43 tm42 p41 0.469414n
Ct43 p41 0 0.111823p
Rt46 p41 tm45 0.000122857
Lt46 tm45 p44 0.0195251n
Ct46 p44 0 0.00465124p
Rt48 p44 tm47 0.00138997
Lt48 tm47 rs_a 0.220901n
Ct48 rs_a 0 0.0526228p
Rser rs_a rs_b 100
Cser rs_b 0 0.1p
Rt51 rs_b tm50 0.00156372
Lt51 tm50 p49 0.248513n
Ct51 p49 0 0.0592006p
Rt54 p49 tm53 0.000122857
Lt54 tm53 p52 0.0195251n
Ct54 p52 0 0.00465124p
Rt57 p52 tm56 0.00277994
Lt57 tm56 p55 0.441802n
Ct57 p55 0 0.105246p
Rt61 p55 tm59 0.00294066
Lt61 tm59 t60 0.467343n
Ct61 t60 0 0.11133p
Rt63 t60 tm62 0.00294066
Lt63 tm62 p58 0.467343n
Ct63 p58 0 0.11133p
Rt66 p58 tm65 6.08112e-05
Lt66 tm65 p64 0.00966441n
Ct66 p64 0 0.00230225p
Rt69 p64 tm68 0.000217183
Lt69 tm68 p67 0.0304261n
Ct69 p67 0 0.00593319p
Rt73 p67 tm71 0.00450291
Lt73 tm71 t72 0.715625n
Ct73 t72 0 0.170475p
Rt76 t72 tm74 0.00450291
Lt76 tm74 t75 0.715625n
Ct76 t75 0 0.170475p
Rt79 t75 tm77 0.00450291
Lt79 tm77 t78 0.715625n
Ct79 t78 0 0.170475p
Rt82 t78 tm80 0.00450291
Lt82 tm80 t81 0.715625n
Ct82 t81 0 0.170475p
Rt85 t81 tm83 0.00450291
Lt85 tm83 t84 0.715625n
Ct85 t84 0 0.170475p
Rt88 t84 tm86 0.00450291
Lt88 tm86 t87 0.715625n
Ct88 t87 0 0.170475p
Rt91 t87 tm89 0.00450291
Lt91 tm89 t90 0.715625n
Ct91 t90 0 0.170475p
Rt94 t90 tm92 0.00450291
Lt94 tm92 t93 0.715625n
Ct94 t93 0 0.170475p
Rt96 t93 tm95 0.00450291
Lt96 tm95 p70 0.715625n
Ct96 p70 0 0.170475p
Rs99 p70 sm98 0.000746971
Ls99 sm98 stubend97 0.118712n
Cs99 stubend97 0 0.0282795p
Cs100 stubend97 0 0.15p
Rt102 p70 tm101 9.43321e-06
Lt102 tm101 din 0.00149917n
Ct102 din 0 0.000357131p
Cin din 0 15p
.tran 0.1n 5000n 0 0.2n
.control
set wr_singlescale
set wr_vecnames
set numdgt=7
run

wrdata /out/led_hop21_weakp.txt v(dout) v(din)
.endc
.end
