* led_hop14_weak: SK6805 DOUT (assumed 500 ohm, 30 ns) -> 100 ohm in series -> routed hop -> DIN 5 pF
Vsrc src 0 PWL(0.0000n 0 100.0000n 0 130.0000n 4 400.0000n 4 430.0000n 0 1300.0000n 0 1330.0000n 4 2200.0000n 4 2230.0000n 0 2500.0000n 0 2530.0000n 4 2800.0000n 4 2830.0000n 0 3700.0000n 0 3730.0000n 4 4600.0000n 4 4630.0000n 0)
Rdrv src dout 500.0
Cdout dout 0 2p
Rt3 dout tm2 0.00122857
Lt3 tm2 p1 0.195251n
Ct3 p1 0 0.0465124p
Rt6 p1 tm5 0.000694985
Lt6 tm5 p4 0.11045n
Ct6 p4 0 0.0263114p
Rt9 p4 tm8 0.00172
Lt9 tm8 p7 0.273351n
Ct9 p7 0 0.0651174p
Rt13 p7 tm11 0.00258
Lt13 tm11 t12 0.410026n
Ct13 t12 0 0.097676p
Rt15 t12 tm14 0.00258
Lt15 tm14 p10 0.410026n
Ct15 p10 0 0.097676p
Rt19 p10 tm17 0.00282571
Lt19 tm17 t18 0.449076n
Ct19 t18 0 0.106979p
Rt21 t18 tm20 0.00282571
Lt21 tm20 p16 0.449076n
Ct21 p16 0 0.106979p
Rt24 p16 tm22 0.00470131
Lt24 tm22 t23 0.747156n
Ct24 t23 0 0.177987p
Rt27 t23 tm25 0.00470131
Lt27 tm25 t26 0.747156n
Ct27 t26 0 0.177987p
Rt30 t26 tm28 0.00470131
Lt30 tm28 t29 0.747156n
Ct30 t29 0 0.177987p
Rt33 t29 tm31 0.00470131
Lt33 tm31 t32 0.747156n
Ct33 t32 0 0.177987p
Rt36 t32 tm34 0.00470131
Lt36 tm34 t35 0.747156n
Ct36 t35 0 0.177987p
Rt38 t35 tm37 0.00470131
Lt38 tm37 rs_a 0.747156n
Ct38 rs_a 0 0.177987p
Rser rs_a rs_b 100
Cser rs_b 0 0.1p
Rt41 rs_b tm39 0.00491019
Lt41 tm39 t40 0.780352n
Ct41 t40 0 0.185895p
Rt44 t40 tm42 0.00491019
Lt44 tm42 t43 0.780352n
Ct44 t43 0 0.185895p
Rt47 t43 tm45 0.00491019
Lt47 tm45 t46 0.780352n
Ct47 t46 0 0.185895p
Rt50 t46 tm48 0.00491019
Lt50 tm48 t49 0.780352n
Ct50 t49 0 0.185895p
Rt53 t49 tm51 0.00491019
Lt53 tm51 t52 0.780352n
Ct53 t52 0 0.185895p
Rt55 t52 tm54 0.00491019
Lt55 tm54 din 0.780352n
Ct55 din 0 0.185895p
Cin din 0 5p
.tran 0.1n 5000n 0 0.2n
.control
set wr_singlescale
set wr_vecnames
set numdgt=7
run

wrdata /out/led_hop14_weak.txt v(dout) v(din)
.endc
.end
