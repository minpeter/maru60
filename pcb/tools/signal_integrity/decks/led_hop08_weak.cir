* led_hop08_weak: SK6805 DOUT (assumed 500 ohm, 30 ns) -> 100 ohm in series -> routed hop -> DIN 5 pF
Vsrc src 0 PWL(0.0000n 0 100.0000n 0 130.0000n 4 400.0000n 4 430.0000n 0 1300.0000n 0 1330.0000n 4 2200.0000n 4 2230.0000n 0 2500.0000n 0 2530.0000n 4 2800.0000n 4 2830.0000n 0 3700.0000n 0 3730.0000n 4 4600.0000n 4 4630.0000n 0)
Rdrv src dout 500.0
Cdout dout 0 2p
Rt3 dout tm1 0.00523775
Lt3 tm1 t2 0.703822n
Ct3 t2 0 0.130503p
Rt6 t2 tm4 0.00523775
Lt6 tm4 t5 0.703822n
Ct6 t5 0 0.130503p
Rt8 t5 tm7 0.00523775
Lt8 tm7 rs_a 0.703822n
Ct8 rs_a 0 0.130503p
Rser rs_a rs_b 100
Cser rs_b 0 0.1p
Rt12 rs_b tm10 0.00458636
Lt12 tm10 t11 0.616291n
Ct12 t11 0 0.114273p
Rt15 t11 tm13 0.00458636
Lt15 tm13 t14 0.616291n
Ct15 t14 0 0.114273p
Rt17 t14 tm16 0.00458636
Lt17 tm16 p9 0.616291n
Ct17 p9 0 0.114273p
Lv19 p9 v18 1.358n
Cv19 v18 0 0.4885p
Rt23 v18 tm21 0.00632304
Lt23 tm21 t22 0.849657n
Ct23 t22 0 0.157544p
Rt26 t22 tm24 0.00632304
Lt26 tm24 t25 0.849657n
Ct26 t25 0 0.157544p
Rt29 t25 tm27 0.00632304
Lt29 tm27 t28 0.849657n
Ct29 t28 0 0.157544p
Rt32 t28 tm30 0.00632304
Lt32 tm30 t31 0.849657n
Ct32 t31 0 0.157544p
Rt35 t31 tm33 0.00632304
Lt35 tm33 t34 0.849657n
Ct35 t34 0 0.157544p
Rt38 t34 tm36 0.00632304
Lt38 tm36 t37 0.849657n
Ct38 t37 0 0.157544p
Rt41 t37 tm39 0.00632304
Lt41 tm39 t40 0.849657n
Ct41 t40 0 0.157544p
Rt44 t40 tm42 0.00632304
Lt44 tm42 t43 0.849657n
Ct44 t43 0 0.157544p
Rt47 t43 tm45 0.00632304
Lt47 tm45 t46 0.849657n
Ct47 t46 0 0.157544p
Rt50 t46 tm48 0.00632304
Lt50 tm48 t49 0.849657n
Ct50 t49 0 0.157544p
Rt53 t49 tm51 0.00632304
Lt53 tm51 t52 0.849657n
Ct53 t52 0 0.157544p
Rt56 t52 tm54 0.00632304
Lt56 tm54 t55 0.849657n
Ct56 t55 0 0.157544p
Rt59 t55 tm57 0.00632304
Lt59 tm57 t58 0.849657n
Ct59 t58 0 0.157544p
Rt62 t58 tm60 0.00632304
Lt62 tm60 t61 0.849657n
Ct62 t61 0 0.157544p
Rt65 t61 tm63 0.00632304
Lt65 tm63 t64 0.849657n
Ct65 t64 0 0.157544p
Rt68 t64 tm66 0.00632304
Lt68 tm66 t67 0.849657n
Ct68 t67 0 0.157544p
Rt71 t67 tm69 0.00632304
Lt71 tm69 t70 0.849657n
Ct71 t70 0 0.157544p
Rt74 t70 tm72 0.00632304
Lt74 tm72 t73 0.849657n
Ct74 t73 0 0.157544p
Rt77 t73 tm75 0.00632304
Lt77 tm75 t76 0.849657n
Ct77 t76 0 0.157544p
Rt80 t76 tm78 0.00632304
Lt80 tm78 t79 0.849657n
Ct80 t79 0 0.157544p
Rt83 t79 tm81 0.00632304
Lt83 tm81 t82 0.849657n
Ct83 t82 0 0.157544p
Rt86 t82 tm84 0.00632304
Lt86 tm84 t85 0.849657n
Ct86 t85 0 0.157544p
Rt88 t85 tm87 0.00632304
Lt88 tm87 p20 0.849657n
Ct88 p20 0 0.157544p
Lv90 p20 v89 1.358n
Cv90 v89 0 0.4885p
Rt92 v89 tm91 0.00257638
Lt92 tm91 din 0.346201n
Ct92 din 0 0.0641926p
Cin din 0 5p
.tran 0.1n 5000n 0 0.2n
.control
set wr_singlescale
set wr_vecnames
set numdgt=7
run

wrdata /out/led_hop08_weak.txt v(dout) v(din)
.endc
.end
