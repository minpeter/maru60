* led_hop08_weak: SK6805 DOUT (assumed 500 ohm, 30 ns) -> routed hop -> DIN 5 pF
Vsrc src 0 PWL(0.0000n 0 100.0000n 0 130.0000n 4 400.0000n 4 430.0000n 0 1300.0000n 0 1330.0000n 4 2200.0000n 4 2230.0000n 0 2500.0000n 0 2530.0000n 4 2800.0000n 4 2830.0000n 0 3700.0000n 0 3730.0000n 4 4600.0000n 4 4630.0000n 0)
Rdrv src dout 500.0
Cdout dout 0 2p
Rt4 dout tm2 0.00361158
Lt4 tm2 t3 0.656199n
Ct4 t3 0 0.189013p
Rt7 t3 tm5 0.00361158
Lt7 tm5 t6 0.656199n
Ct7 t6 0 0.189013p
Rt10 t6 tm8 0.00361158
Lt10 tm8 t9 0.656199n
Ct10 t9 0 0.189013p
Rt13 t9 tm11 0.00361158
Lt13 tm11 t12 0.656199n
Ct13 t12 0 0.189013p
Rt16 t12 tm14 0.00361158
Lt16 tm14 t15 0.656199n
Ct16 t15 0 0.189013p
Rt19 t15 tm17 0.00361158
Lt19 tm17 t18 0.656199n
Ct19 t18 0 0.189013p
Rt22 t18 tm20 0.00361158
Lt22 tm20 t21 0.656199n
Ct22 t21 0 0.189013p
Rt25 t21 tm23 0.00361158
Lt25 tm23 t24 0.656199n
Ct25 t24 0 0.189013p
Rt28 t24 tm26 0.00361158
Lt28 tm26 t27 0.656199n
Ct28 t27 0 0.189013p
Rt31 t27 tm29 0.00361158
Lt31 tm29 t30 0.656199n
Ct31 t30 0 0.189013p
Rt34 t30 tm32 0.00361158
Lt34 tm32 t33 0.656199n
Ct34 t33 0 0.189013p
Rt36 t33 tm35 0.00361158
Lt36 tm35 p1 0.656199n
Ct36 p1 0 0.189013p
Rt39 p1 tm38 6.27234e-06
Lt39 tm38 p37 0.000996832n
Ct39 p37 0 0.000237464p
Rs43 p37 sm41 0.00430442
Ls43 sm41 s42 0.68408n
Cs43 s42 0 0.162961p
Rs46 s42 sm44 0.00430442
Ls46 sm44 s45 0.68408n
Cs46 s45 0 0.162961p
Rs49 s45 sm47 0.00430442
Ls49 sm47 s48 0.68408n
Cs49 s48 0 0.162961p
Rs52 s48 sm50 0.00430442
Ls52 sm50 s51 0.68408n
Cs52 s51 0 0.162961p
Rs54 s51 sm53 0.00430442
Ls54 sm53 stubend40 0.68408n
Cs54 stubend40 0 0.162961p
Cs55 stubend40 0 0.15p
Rt59 p37 tm57 0.00466857
Lt59 tm57 t58 0.741952n
Ct59 t58 0 0.176747p
Rt62 t58 tm60 0.00466857
Lt62 tm60 t61 0.741952n
Ct62 t61 0 0.176747p
Rt65 t61 tm63 0.00466857
Lt65 tm63 t64 0.741952n
Ct65 t64 0 0.176747p
Rt68 t64 tm66 0.00466857
Lt68 tm66 t67 0.741952n
Ct68 t67 0 0.176747p
Rt71 t67 tm69 0.00466857
Lt71 tm69 t70 0.741952n
Ct71 t70 0 0.176747p
Rt74 t70 tm72 0.00466857
Lt74 tm72 t73 0.741952n
Ct74 t73 0 0.176747p
Rt76 t73 tm75 0.00466857
Lt76 tm75 p56 0.741952n
Ct76 p56 0 0.176747p
Rs80 p56 sm78 0.00466857
Ls80 sm78 s79 0.741952n
Cs80 s79 0 0.176747p
Rs83 s79 sm81 0.00466857
Ls83 sm81 s82 0.741952n
Cs83 s82 0 0.176747p
Rs86 s82 sm84 0.00466857
Ls86 sm84 s85 0.741952n
Cs86 s85 0 0.176747p
Rs89 s85 sm87 0.00466857
Ls89 sm87 s88 0.741952n
Cs89 s88 0 0.176747p
Rs92 s88 sm90 0.00466857
Ls92 sm90 s91 0.741952n
Cs92 s91 0 0.176747p
Rs95 s91 sm93 0.00466857
Ls95 sm93 s94 0.741952n
Cs95 s94 0 0.176747p
Rs98 s94 sm96 0.00466857
Ls98 sm96 s97 0.741952n
Cs98 s97 0 0.176747p
Rs101 s97 sm99 0.00466857
Ls101 sm99 s100 0.741952n
Cs101 s100 0 0.176747p
Rs103 s100 sm102 0.00466857
Ls103 sm102 stubend77 0.741952n
Cs103 stubend77 0 0.176747p
Cs104 stubend77 0 0.4885p
Cs105 stubend77 0 0.15p
Rt108 p56 tm106 0.00441291
Lt108 tm106 t107 0.701322n
Ct108 t107 0 0.167068p
Rt111 t107 tm109 0.00441291
Lt111 tm109 t110 0.701322n
Ct111 t110 0 0.167068p
Rt113 t110 tm112 0.00441291
Lt113 tm112 din 0.701322n
Ct113 din 0 0.167068p
Cin din 0 5p
.tran 0.1n 5000n 0 0.2n
.control
set wr_singlescale
set wr_vecnames
set numdgt=7
run

wrdata /out/led_hop08_weak.txt v(dout) v(din)
.endc
.end
