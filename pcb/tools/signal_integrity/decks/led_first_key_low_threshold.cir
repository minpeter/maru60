* led_first_key_low_threshold: RP2350 GPIO -> SN74LV1T125 at 4.0 V -> 330R -> first LED (low threshold)
Vsrc src 0 PWL(0.0000n 0 100.0000n 0 101.5000n 3.3 400.0000n 3.3 401.5000n 0 1300.0000n 0 1301.5000n 3.3 2200.0000n 3.3 2201.5000n 0 2500.0000n 0 2501.5000n 3.3 2800.0000n 3.3 2801.5000n 0 3700.0000n 0 3701.5000n 3.3 4600.0000n 3.3 4601.5000n 0)
Rgpio src gpio 40
Cgpio gpio 0 3p
Rt4 gpio tm2 0.00492981
Lt4 tm2 t3 0.662442n
Ct4 t3 0 0.12283p
Rt7 t3 tm5 0.00492981
Lt7 tm5 t6 0.662442n
Ct7 t6 0 0.12283p
Rt9 t6 tm8 0.00492981
Lt9 tm8 p1 0.662442n
Ct9 p1 0 0.12283p
Lv11 p1 v10 1.358n
Cv11 v10 0 0.4885p
Rt15 v10 tm13 0.00590928
Lt15 tm13 t14 0.794059n
Ct15 t14 0 0.147234p
Rt18 t14 tm16 0.00590928
Lt18 tm16 t17 0.794059n
Ct18 t17 0 0.147234p
Rt21 t17 tm19 0.00590928
Lt21 tm19 t20 0.794059n
Ct21 t20 0 0.147234p
Rt23 t20 tm22 0.00590928
Lt23 tm22 p12 0.794059n
Ct23 p12 0 0.147234p
Lv25 p12 v24 1.358n
Cv25 v24 0 0.4885p
Rt28 v24 tm26 0.00519894
Lt28 tm26 t27 0.698607n
Ct28 t27 0 0.129536p
Rt31 t27 tm29 0.00519894
Lt31 tm29 t30 0.698607n
Ct31 t30 0 0.129536p
Rt33 t30 tm32 0.00519894
Lt33 tm32 bufin 0.698607n
Ct33 bufin 0 0.129536p
Cbufin bufin 0 2p
Bthr thr 0 V=4.0/(1+exp(-(v(bufin)-0.8)/0.03))
Rthr thr dly_in 50
Tdly dly_in 0 dly_out 0 Z0=50 TD=2.5n
Rdly dly_out 0 50
Eshp shp 0 dly_out 0 2
Rshp shp shpc 1k
Cshp shpc 0 0.4545p
Ebuf bufi 0 shpc 0 1
Rbuf bufi bufout 15
Cbufout bufout 0 2.5p
Rt37 bufout tm35 0.0033334
Lt37 tm35 t36 0.447925n
Ct37 t36 0 0.0830543p
Rt39 t36 tm38 0.0033334
Lt39 tm38 p34 0.447925n
Ct39 p34 0 0.0830543p
Lv41 p34 v40 1.358n
Cv41 v40 0 0.4885p
Rt45 v40 tm43 0.00555868
Lt45 tm43 t44 0.746947n
Ct45 t44 0 0.138499p
Rt48 t44 tm46 0.00555868
Lt48 tm46 t47 0.746947n
Ct48 t47 0 0.138499p
Rt51 t47 tm49 0.00555868
Lt51 tm49 t50 0.746947n
Ct51 t50 0 0.138499p
Rt54 t50 tm52 0.00555868
Lt54 tm52 t53 0.746947n
Ct54 t53 0 0.138499p
Rt56 t53 tm55 0.00555868
Lt56 tm55 p42 0.746947n
Ct56 p42 0 0.138499p
Lv58 p42 v57 1.358n
Cv58 v57 0 0.4885p
Rt60 v57 tm59 0.00393143
Lt60 tm59 rin 0.528285n
Ct60 rin 0 0.0979546p
R110 rin rout 330
Crpad rout 0 0.1p
Rs63 rout sm62 0.000914057
Ls63 sm62 stubend61 0.145266n
Cs63 stubend61 0 0.0346052p
Cs64 stubend61 0 0.15p
Rt68 rout tm66 0.00462481
Lt68 tm66 t67 0.621458n
Ct68 t67 0 0.115231p
Rt71 t67 tm69 0.00462481
Lt71 tm69 t70 0.621458n
Ct71 t70 0 0.115231p
Rt73 t70 tm72 0.00462481
Lt73 tm72 p65 0.621458n
Ct73 p65 0 0.115231p
Lv75 p65 v74 1.358n
Cv75 v74 0 0.4885p
Rt79 v74 tm77 0.00636827
Lt79 tm77 t78 0.855735n
Ct79 t78 0 0.15867p
Rt82 t78 tm80 0.00636827
Lt82 tm80 t81 0.855735n
Ct82 t81 0 0.15867p
Rt85 t81 tm83 0.00636827
Lt85 tm83 t84 0.855735n
Ct85 t84 0 0.15867p
Rt88 t84 tm86 0.00636827
Lt88 tm86 t87 0.855735n
Ct88 t87 0 0.15867p
Rt91 t87 tm89 0.00636827
Lt91 tm89 t90 0.855735n
Ct91 t90 0 0.15867p
Rt94 t90 tm92 0.00636827
Lt94 tm92 t93 0.855735n
Ct94 t93 0 0.15867p
Rt97 t93 tm95 0.00636827
Lt97 tm95 t96 0.855735n
Ct97 t96 0 0.15867p
Rt100 t96 tm98 0.00636827
Lt100 tm98 t99 0.855735n
Ct100 t99 0 0.15867p
Rt102 t99 tm101 0.00636827
Lt102 tm101 p76 0.855735n
Ct102 p76 0 0.15867p
Lv104 p76 v103 1.358n
Cv104 v103 0 0.4885p
Rt108 v103 tm106 0.00631248
Lt108 tm106 t107 0.848239n
Ct108 t107 0 0.15728p
Rt111 t107 tm109 0.00631248
Lt111 tm109 t110 0.848239n
Ct111 t110 0 0.15728p
Rt114 t110 tm112 0.00631248
Lt114 tm112 t113 0.848239n
Ct114 t113 0 0.15728p
Rt117 t113 tm115 0.00631248
Lt117 tm115 t116 0.848239n
Ct117 t116 0 0.15728p
Rt120 t116 tm118 0.00631248
Lt120 tm118 t119 0.848239n
Ct120 t119 0 0.15728p
Rt123 t119 tm121 0.00631248
Lt123 tm121 t122 0.848239n
Ct123 t122 0 0.15728p
Rt126 t122 tm124 0.00631248
Lt126 tm124 t125 0.848239n
Ct126 t125 0 0.15728p
Rt129 t125 tm127 0.00631248
Lt129 tm127 t128 0.848239n
Ct129 t128 0 0.15728p
Rt132 t128 tm130 0.00631248
Lt132 tm130 t131 0.848239n
Ct132 t131 0 0.15728p
Rt135 t131 tm133 0.00631248
Lt135 tm133 t134 0.848239n
Ct135 t134 0 0.15728p
Rt138 t134 tm136 0.00631248
Lt138 tm136 t137 0.848239n
Ct138 t137 0 0.15728p
Rt141 t137 tm139 0.00631248
Lt141 tm139 t140 0.848239n
Ct141 t140 0 0.15728p
Rt144 t140 tm142 0.00631248
Lt144 tm142 t143 0.848239n
Ct144 t143 0 0.15728p
Rt147 t143 tm145 0.00631248
Lt147 tm145 t146 0.848239n
Ct147 t146 0 0.15728p
Rt150 t146 tm148 0.00631248
Lt150 tm148 t149 0.848239n
Ct150 t149 0 0.15728p
Rt153 t149 tm151 0.00631248
Lt153 tm151 t152 0.848239n
Ct153 t152 0 0.15728p
Rt156 t152 tm154 0.00631248
Lt156 tm154 t155 0.848239n
Ct156 t155 0 0.15728p
Rt159 t155 tm157 0.00631248
Lt159 tm157 t158 0.848239n
Ct159 t158 0 0.15728p
Rt162 t158 tm160 0.00631248
Lt162 tm160 t161 0.848239n
Ct162 t161 0 0.15728p
Rt165 t161 tm163 0.00631248
Lt165 tm163 t164 0.848239n
Ct165 t164 0 0.15728p
Rt168 t164 tm166 0.00631248
Lt168 tm166 t167 0.848239n
Ct168 t167 0 0.15728p
Rt170 t167 tm169 0.00631248
Lt170 tm169 p105 0.848239n
Ct170 p105 0 0.15728p
Lv172 p105 v171 1.358n
Cv172 v171 0 0.4885p
Rt176 v171 tm174 0.00607812
Lt176 tm174 t175 0.816746n
Ct176 t175 0 0.151441p
Rt179 t175 tm177 0.00607812
Lt179 tm177 t178 0.816746n
Ct179 t178 0 0.151441p
Rt182 t178 tm180 0.00607812
Lt182 tm180 t181 0.816746n
Ct182 t181 0 0.151441p
Rt185 t181 tm183 0.00607812
Lt185 tm183 t184 0.816746n
Ct185 t184 0 0.151441p
Rt188 t184 tm186 0.00607812
Lt188 tm186 t187 0.816746n
Ct188 t187 0 0.151441p
Rt191 t187 tm189 0.00607812
Lt191 tm189 t190 0.816746n
Ct191 t190 0 0.151441p
Rt194 t190 tm192 0.00607812
Lt194 tm192 t193 0.816746n
Ct194 t193 0 0.151441p
Rt197 t193 tm195 0.00607812
Lt197 tm195 t196 0.816746n
Ct197 t196 0 0.151441p
Rt199 t196 tm198 0.00607812
Lt199 tm198 p173 0.816746n
Ct199 p173 0 0.151441p
Lv201 p173 v200 1.358n
Cv201 v200 0 0.4885p
Rt205 v200 tm203 0.00651388
Lt205 tm203 t204 0.875302n
Ct205 t204 0 0.162298p
Rt208 t204 tm206 0.00651388
Lt208 tm206 t207 0.875302n
Ct208 t207 0 0.162298p
Rt211 t207 tm209 0.00651388
Lt211 tm209 t210 0.875302n
Ct211 t210 0 0.162298p
Rt214 t210 tm212 0.00651388
Lt214 tm212 t213 0.875302n
Ct214 t213 0 0.162298p
Rt217 t213 tm215 0.00651388
Lt217 tm215 t216 0.875302n
Ct217 t216 0 0.162298p
Rt220 t216 tm218 0.00651388
Lt220 tm218 t219 0.875302n
Ct220 t219 0 0.162298p
Rt223 t219 tm221 0.00651388
Lt223 tm221 t222 0.875302n
Ct223 t222 0 0.162298p
Rt225 t222 tm224 0.00651388
Lt225 tm224 p202 0.875302n
Ct225 p202 0 0.162298p
Lv227 p202 v226 1.358n
Cv227 v226 0 0.4885p
Rt231 v226 tm229 0.00627052
Lt231 tm229 t230 0.842601n
Ct231 t230 0 0.156235p
Rt234 t230 tm232 0.00627052
Lt234 tm232 t233 0.842601n
Ct234 t233 0 0.156235p
Rt237 t233 tm235 0.00627052
Lt237 tm235 t236 0.842601n
Ct237 t236 0 0.156235p
Rt240 t236 tm238 0.00627052
Lt240 tm238 t239 0.842601n
Ct240 t239 0 0.156235p
Rt243 t239 tm241 0.00627052
Lt243 tm241 t242 0.842601n
Ct243 t242 0 0.156235p
Rt245 t242 tm244 0.00627052
Lt245 tm244 p228 0.842601n
Ct245 p228 0 0.156235p
Lv247 p228 v246 1.358n
Cv247 v246 0 0.4885p
Rt251 v246 tm249 0.00618853
Lt251 tm249 t250 0.831583n
Ct251 t250 0 0.154192p
Rt254 t250 tm252 0.00618853
Lt254 tm252 t253 0.831583n
Ct254 t253 0 0.154192p
Rt257 t253 tm255 0.00618853
Lt257 tm255 t256 0.831583n
Ct257 t256 0 0.154192p
Rt260 t256 tm258 0.00618853
Lt260 tm258 t259 0.831583n
Ct260 t259 0 0.154192p
Rt263 t259 tm261 0.00618853
Lt263 tm261 t262 0.831583n
Ct263 t262 0 0.154192p
Rt266 t262 tm264 0.00618853
Lt266 tm264 t265 0.831583n
Ct266 t265 0 0.154192p
Rt269 t265 tm267 0.00618853
Lt269 tm267 t268 0.831583n
Ct269 t268 0 0.154192p
Rt271 t268 tm270 0.00618853
Lt271 tm270 p248 0.831583n
Ct271 p248 0 0.154192p
Lv273 p248 v272 1.358n
Cv273 v272 0 0.4885p
Rt276 v272 tm274 0.00654521
Lt276 tm274 t275 0.879511n
Ct276 t275 0 0.163079p
Rt279 t275 tm277 0.00654521
Lt279 tm277 t278 0.879511n
Ct279 t278 0 0.163079p
Rt282 t278 tm280 0.00654521
Lt282 tm280 t281 0.879511n
Ct282 t281 0 0.163079p
Rt285 t281 tm283 0.00654521
Lt285 tm283 t284 0.879511n
Ct285 t284 0 0.163079p
Rt288 t284 tm286 0.00654521
Lt288 tm286 t287 0.879511n
Ct288 t287 0 0.163079p
Rt291 t287 tm289 0.00654521
Lt291 tm289 t290 0.879511n
Ct291 t290 0 0.163079p
Rt293 t290 tm292 0.00654521
Lt293 tm292 din 0.879511n
Ct293 din 0 0.163079p
Cin din 0 5p
.tran 0.1n 5000n 0 0.2n
.control
set wr_singlescale
set wr_vecnames
set numdgt=7
run

wrdata /out/led_first_key_low_threshold.txt v(gpio) v(bufin) v(bufout) v(din)
.endc
.end
