* led_hop28_weak: SK6805 DOUT (assumed 500 ohm, 30 ns) -> 100 ohm in series -> routed hop -> DIN 5 pF
Vsrc src 0 PWL(0.0000n 0 100.0000n 0 130.0000n 4 400.0000n 4 430.0000n 0 1300.0000n 0 1330.0000n 4 2200.0000n 4 2230.0000n 0 2500.0000n 0 2530.0000n 4 2800.0000n 4 2830.0000n 0 3700.0000n 0 3730.0000n 4 4600.0000n 4 4630.0000n 0)
Rdrv src dout 500.0
Cdout dout 0 2p
Rt4 dout tm2 0.00361158
Lt4 tm2 t3 0.656199n
Ct4 t3 0 0.189013p
Rt7 t3 tm5 0.00361158
Lt7 tm5 t6 0.656199n
Ct7 t6 0 0.189013p
Rt10 t6 tm8 0.00361158
Lt10 tm8 t9 0.656199n
Ct10 t9 0 0.189013p
Rt13 t9 tm11 0.00361158
Lt13 tm11 t12 0.656199n
Ct13 t12 0 0.189013p
Rt16 t12 tm14 0.00361158
Lt16 tm14 t15 0.656199n
Ct16 t15 0 0.189013p
Rt19 t15 tm17 0.00361158
Lt19 tm17 t18 0.656199n
Ct19 t18 0 0.189013p
Rt22 t18 tm20 0.00361158
Lt22 tm20 t21 0.656199n
Ct22 t21 0 0.189013p
Rt25 t21 tm23 0.00361158
Lt25 tm23 t24 0.656199n
Ct25 t24 0 0.189013p
Rt28 t24 tm26 0.00361158
Lt28 tm26 t27 0.656199n
Ct28 t27 0 0.189013p
Rt31 t27 tm29 0.00361158
Lt31 tm29 t30 0.656199n
Ct31 t30 0 0.189013p
Rt34 t30 tm32 0.00361158
Lt34 tm32 t33 0.656199n
Ct34 t33 0 0.189013p
Rt36 t33 tm35 0.00361158
Lt36 tm35 p1 0.656199n
Ct36 p1 0 0.189013p
Rt39 p1 tm38 6.27234e-06
Lt39 tm38 p37 0.000996832n
Ct39 p37 0 0.000237464p
Rs43 p37 sm41 0.00430442
Ls43 sm41 s42 0.68408n
Cs43 s42 0 0.162961p
Rs46 s42 sm44 0.00430442
Ls46 sm44 s45 0.68408n
Cs46 s45 0 0.162961p
Rs49 s45 sm47 0.00430442
Ls49 sm47 s48 0.68408n
Cs49 s48 0 0.162961p
Rs52 s48 sm50 0.00430442
Ls52 sm50 s51 0.68408n
Cs52 s51 0 0.162961p
Rs54 s51 sm53 0.00430442
Ls54 sm53 stubend40 0.68408n
Cs54 stubend40 0 0.162961p
Cs55 stubend40 0 0.15p
Rt58 p37 tm57 1.11023e-05
Lt58 tm57 p56 0.00176443n
Ct58 p56 0 0.00042032p
Rt61 p56 tm60 0.0044698
Lt61 tm60 p59 0.710362n
Ct61 p59 0 0.169222p
Rt65 p59 tm63 0.00405429
Lt65 tm63 t64 0.644327n
Ct65 t64 0 0.153491p
Rt67 t64 tm66 0.00405429
Lt67 tm66 p62 0.644327n
Ct67 p62 0 0.153491p
Rt71 p62 tm69 0.00319429
Lt71 tm69 t70 0.507652n
Ct71 t70 0 0.120932p
Rt73 t70 tm72 0.00319429
Lt73 tm72 p68 0.507652n
Ct73 p68 0 0.120932p
Rt76 p68 tm75 0.00355924
Lt76 tm75 p74 0.565652n
Ct76 p74 0 0.134749p
Lv78 p74 v77 1.358n
Cv78 v77 0 0.4885p
Rt80 v77 tm79 0.00393119
Lt80 tm79 rs_a 0.624764n
Ct80 rs_a 0 0.148831p
Rser rs_a rs_b 100
Cser rs_b 0 0.1p
Rt83 rs_b tm82 0.001204
Lt83 tm82 p81 0.191346n
Ct83 p81 0 0.0455821p
Rs87 p81 sm85 0.00482214
Ls87 sm85 s86 0.766359n
Cs87 s86 0 0.182561p
Rs90 s86 sm88 0.00482214
Ls90 sm88 s89 0.766359n
Cs90 s89 0 0.182561p
Rs93 s89 sm91 0.00482214
Ls93 sm91 s92 0.766359n
Cs93 s92 0 0.182561p
Rs96 s92 sm94 0.00482214
Ls96 sm94 s95 0.766359n
Cs96 s95 0 0.182561p
Rs99 s95 sm97 0.00482214
Ls99 sm97 s98 0.766359n
Cs99 s98 0 0.182561p
Rs102 s98 sm100 0.00482214
Ls102 sm100 s101 0.766359n
Cs102 s101 0 0.182561p
Rs105 s101 sm103 0.00482214
Ls105 sm103 s104 0.766359n
Cs105 s104 0 0.182561p
Rs107 s104 sm106 0.00482214
Ls107 sm106 stubend84 0.766359n
Cs107 stubend84 0 0.182561p
Cs108 stubend84 0 0.15p
Rt111 p81 tm110 9.98773e-06
Lt111 tm110 p109 0.0015873n
Ct111 p109 0 0.000378125p
Rt114 p109 tm113 0.002752
Lt114 tm113 p112 0.500019n
Ct114 p112 0 0.144027p
Lv116 p112 v115 1.358n
Cv116 v115 0 0.4885p
Rt119 v115 tm117 0.00441003
Lt119 tm117 t118 0.700864n
Ct119 t118 0 0.166959p
Rt122 t118 tm120 0.00441003
Lt122 tm120 t121 0.700864n
Ct122 t121 0 0.166959p
Rt124 t121 tm123 0.00441003
Lt124 tm123 din 0.700864n
Ct124 din 0 0.166959p
Cin din 0 5p
.tran 0.1n 5000n 0 0.2n
.control
set wr_singlescale
set wr_vecnames
set numdgt=7
run

wrdata /out/led_hop28_weak.txt v(dout) v(din)
.endc
.end
