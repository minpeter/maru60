* led_hop19_nom: SK6805 DOUT (assumed 100 ohm, 10 ns) -> 100 ohm in series -> routed hop -> DIN 5 pF
Vsrc src 0 PWL(0.0000n 0 100.0000n 0 110.0000n 4 400.0000n 4 410.0000n 0 1300.0000n 0 1310.0000n 4 2200.0000n 4 2210.0000n 0 2500.0000n 0 2510.0000n 4 2800.0000n 4 2810.0000n 0 3700.0000n 0 3710.0000n 4 4600.0000n 4 4610.0000n 0)
Rdrv src dout 100.0
Cdout dout 0 2p
Rt3 dout tm2 0.00268975
Lt3 tm2 p1 0.361435n
Ct3 p1 0 0.0670173p
Lv5 p1 v4 1.358n
Cv5 v4 0 0.4885p
Rt9 v4 tm7 0.00543684
Lt9 tm7 t8 0.730574n
Ct9 t8 0 0.135463p
Rt11 t8 tm10 0.00543684
Lt11 tm10 p6 0.730574n
Ct11 p6 0 0.135463p
Rs15 p6 sm13 0.00412431
Ls15 sm13 s14 0.655456n
Cs15 s14 0 0.156142p
Rs18 s14 sm16 0.00412431
Ls18 sm16 s17 0.655456n
Cs18 s17 0 0.156142p
Rs21 s17 sm19 0.00412431
Ls21 sm19 s20 0.655456n
Cs21 s20 0 0.156142p
Rs24 s20 sm22 0.00412431
Ls24 sm22 s23 0.655456n
Cs24 s23 0 0.156142p
Rs27 s23 sm25 0.00412431
Ls27 sm25 s26 0.655456n
Cs27 s26 0 0.156142p
Rs29 s26 sm28 0.00412431
Ls29 sm28 stubend12 0.655456n
Cs29 stubend12 0 0.156142p
Cs30 stubend12 0 0.4885p
Cs31 stubend12 0 0.15p
Rt33 p6 tm32 0.00544056
Lt33 tm32 rs_a 0.731074n
Ct33 rs_a 0 0.135556p
Rser rs_a rs_b 100
Cser rs_b 0 0.1p
Rt37 rs_b tm35 0.00584566
Lt37 tm35 t36 0.78551n
Ct37 t36 0 0.145649p
Rt40 t36 tm38 0.00584566
Lt40 tm38 t39 0.78551n
Ct40 t39 0 0.145649p
Rt43 t39 tm41 0.00584566
Lt43 tm41 t42 0.78551n
Ct43 t42 0 0.145649p
Rt46 t42 tm44 0.00584566
Lt46 tm44 t45 0.78551n
Ct46 t45 0 0.145649p
Rt49 t45 tm47 0.00584566
Lt49 tm47 t48 0.78551n
Ct49 t48 0 0.145649p
Rt52 t48 tm50 0.00584566
Lt52 tm50 t51 0.78551n
Ct52 t51 0 0.145649p
Rt54 t51 tm53 0.00584566
Lt54 tm53 p34 0.78551n
Ct54 p34 0 0.145649p
Lv56 p34 v55 1.358n
Cv56 v55 0 0.4885p
Rt59 v55 tm57 0.00653592
Lt59 tm57 t58 0.878263n
Ct59 t58 0 0.162847p
Rt61 t58 tm60 0.00653592
Lt61 tm60 din 0.878263n
Ct61 din 0 0.162847p
Cin din 0 5p
.tran 0.1n 5000n 0 0.2n
.control
set wr_singlescale
set wr_vecnames
set numdgt=7
run

wrdata /out/led_hop19_nom.txt v(dout) v(din)
.endc
.end
