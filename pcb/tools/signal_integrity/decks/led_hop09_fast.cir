* led_hop09_fast: SK6805 DOUT (assumed 20 ohm, 2 ns) -> 100 ohm in series -> routed hop -> DIN 5 pF
Vsrc src 0 PWL(0.0000n 0 100.0000n 0 102.0000n 4 400.0000n 4 402.0000n 0 1300.0000n 0 1302.0000n 4 2200.0000n 4 2202.0000n 0 2500.0000n 0 2502.0000n 4 2800.0000n 4 2802.0000n 0 3700.0000n 0 3702.0000n 4 4600.0000n 4 4602.0000n 0)
Rdrv src dout 20.0
Cdout dout 0 2p
Rt2 dout tm1 0.00555306
Lt2 tm1 rs_a 0.746192n
Ct2 rs_a 0 0.138359p
Rser rs_a rs_b 100
Cser rs_b 0 0.1p
Rt5 rs_b tm4 0.00234938
Lt5 tm4 p3 0.315697n
Ct5 p3 0 0.0585366p
Lv7 p3 v6 1.358n
Cv7 v6 0 0.4885p
Rt11 v6 tm9 0.00648597
Lt11 tm9 t10 0.871551n
Ct11 t10 0 0.161603p
Rt14 t10 tm12 0.00648597
Lt14 tm12 t13 0.871551n
Ct14 t13 0 0.161603p
Rt17 t13 tm15 0.00648597
Lt17 tm15 t16 0.871551n
Ct17 t16 0 0.161603p
Rt20 t16 tm18 0.00648597
Lt20 tm18 t19 0.871551n
Ct20 t19 0 0.161603p
Rt23 t19 tm21 0.00648597
Lt23 tm21 t22 0.871551n
Ct23 t22 0 0.161603p
Rt26 t22 tm24 0.00648597
Lt26 tm24 t25 0.871551n
Ct26 t25 0 0.161603p
Rt29 t25 tm27 0.00648597
Lt29 tm27 t28 0.871551n
Ct29 t28 0 0.161603p
Rt32 t28 tm30 0.00648597
Lt32 tm30 t31 0.871551n
Ct32 t31 0 0.161603p
Rt35 t31 tm33 0.00648597
Lt35 tm33 t34 0.871551n
Ct35 t34 0 0.161603p
Rt38 t34 tm36 0.00648597
Lt38 tm36 t37 0.871551n
Ct38 t37 0 0.161603p
Rt41 t37 tm39 0.00648597
Lt41 tm39 t40 0.871551n
Ct41 t40 0 0.161603p
Rt44 t40 tm42 0.00648597
Lt44 tm42 t43 0.871551n
Ct44 t43 0 0.161603p
Rt47 t43 tm45 0.00648597
Lt47 tm45 t46 0.871551n
Ct47 t46 0 0.161603p
Rt50 t46 tm48 0.00648597
Lt50 tm48 t49 0.871551n
Ct50 t49 0 0.161603p
Rt53 t49 tm51 0.00648597
Lt53 tm51 t52 0.871551n
Ct53 t52 0 0.161603p
Rt56 t52 tm54 0.00648597
Lt56 tm54 t55 0.871551n
Ct56 t55 0 0.161603p
Rt59 t55 tm57 0.00648597
Lt59 tm57 t58 0.871551n
Ct59 t58 0 0.161603p
Rt62 t58 tm60 0.00648597
Lt62 tm60 t61 0.871551n
Ct62 t61 0 0.161603p
Rt65 t61 tm63 0.00648597
Lt65 tm63 t64 0.871551n
Ct65 t64 0 0.161603p
Rt68 t64 tm66 0.00648597
Lt68 tm66 t67 0.871551n
Ct68 t67 0 0.161603p
Rt71 t67 tm69 0.00648597
Lt71 tm69 t70 0.871551n
Ct71 t70 0 0.161603p
Rt74 t70 tm72 0.00648597
Lt74 tm72 t73 0.871551n
Ct74 t73 0 0.161603p
Rt77 t73 tm75 0.00648597
Lt77 tm75 t76 0.871551n
Ct77 t76 0 0.161603p
Rt80 t76 tm78 0.00648597
Lt80 tm78 t79 0.871551n
Ct80 t79 0 0.161603p
Rt83 t79 tm81 0.00648597
Lt83 tm81 t82 0.871551n
Ct83 t82 0 0.161603p
Rt86 t82 tm84 0.00648597
Lt86 tm84 t85 0.871551n
Ct86 t85 0 0.161603p
Rt88 t85 tm87 0.00648597
Lt88 tm87 p8 0.871551n
Ct88 p8 0 0.161603p
Lv90 p8 v89 1.358n
Cv90 v89 0 0.4885p
Rt92 v89 tm91 0.00493757
Lt92 tm91 din 0.663485n
Ct92 din 0 0.123023p
Cin din 0 5p
.tran 0.1n 5000n 0 0.2n
.control
set wr_singlescale
set wr_vecnames
set numdgt=7
run

wrdata /out/led_hop09_fast.txt v(dout) v(din)
.endc
.end
