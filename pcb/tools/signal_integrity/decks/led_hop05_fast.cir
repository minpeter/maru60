* led_hop05_fast: SK6805 DOUT (assumed 20 ohm, 2 ns) -> 100 ohm in series -> routed hop -> DIN 5 pF
Vsrc src 0 PWL(0.0000n 0 100.0000n 0 102.0000n 4 400.0000n 4 402.0000n 0 1300.0000n 0 1302.0000n 4 2200.0000n 4 2202.0000n 0 2500.0000n 0 2502.0000n 4 2800.0000n 4 2802.0000n 0 3700.0000n 0 3702.0000n 4 4600.0000n 4 4602.0000n 0)
Rdrv src dout 20.0
Cdout dout 0 2p
Rt3 dout tm1 0.00592259
Lt3 tm1 t2 0.795847n
Ct3 t2 0 0.147566p
Rt6 t2 tm4 0.00592259
Lt6 tm4 t5 0.795847n
Ct6 t5 0 0.147566p
Rt9 t5 tm7 0.00592259
Lt9 tm7 t8 0.795847n
Ct9 t8 0 0.147566p
Rt12 t8 tm10 0.00592259
Lt12 tm10 t11 0.795847n
Ct12 t11 0 0.147566p
Rt14 t11 tm13 0.00592259
Lt14 tm13 rs_a 0.795847n
Ct14 rs_a 0 0.147566p
Rser rs_a rs_b 100
Cser rs_b 0 0.1p
Rt18 rs_b tm16 0.00502867
Lt18 tm16 t17 0.675727n
Ct18 t17 0 0.125293p
Rt21 t17 tm19 0.00502867
Lt21 tm19 t20 0.675727n
Ct21 t20 0 0.125293p
Rt23 t20 tm22 0.00502867
Lt23 tm22 p15 0.675727n
Ct23 p15 0 0.125293p
Lv25 p15 v24 1.358n
Cv25 v24 0 0.4885p
Rt29 v24 tm27 0.0060662
Lt29 tm27 t28 0.815145n
Ct29 t28 0 0.151144p
Rt32 t28 tm30 0.0060662
Lt32 tm30 t31 0.815145n
Ct32 t31 0 0.151144p
Rt35 t31 tm33 0.0060662
Lt35 tm33 t34 0.815145n
Ct35 t34 0 0.151144p
Rt38 t34 tm36 0.0060662
Lt38 tm36 t37 0.815145n
Ct38 t37 0 0.151144p
Rt41 t37 tm39 0.0060662
Lt41 tm39 t40 0.815145n
Ct41 t40 0 0.151144p
Rt44 t40 tm42 0.0060662
Lt44 tm42 t43 0.815145n
Ct44 t43 0 0.151144p
Rt47 t43 tm45 0.0060662
Lt47 tm45 t46 0.815145n
Ct47 t46 0 0.151144p
Rt50 t46 tm48 0.0060662
Lt50 tm48 t49 0.815145n
Ct50 t49 0 0.151144p
Rt53 t49 tm51 0.0060662
Lt53 tm51 t52 0.815145n
Ct53 t52 0 0.151144p
Rt56 t52 tm54 0.0060662
Lt56 tm54 t55 0.815145n
Ct56 t55 0 0.151144p
Rt59 t55 tm57 0.0060662
Lt59 tm57 t58 0.815145n
Ct59 t58 0 0.151144p
Rt61 t58 tm60 0.0060662
Lt61 tm60 p26 0.815145n
Ct61 p26 0 0.151144p
Lv63 p26 v62 1.358n
Cv63 v62 0 0.4885p
Rt65 v62 tm64 0.00276007
Lt65 tm64 din 0.370884n
Ct65 din 0 0.0687693p
Cin din 0 5p
.tran 0.1n 5000n 0 0.2n
.control
set wr_singlescale
set wr_vecnames
set numdgt=7
run

wrdata /out/led_hop05_fast.txt v(dout) v(din)
.endc
.end
