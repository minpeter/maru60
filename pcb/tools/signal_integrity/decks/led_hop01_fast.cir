* led_hop01_fast: SK6805 DOUT (assumed 20 ohm, 2 ns) -> routed hop -> DIN 5 pF
Vsrc src 0 PWL(0.0000n 0 100.0000n 0 102.0000n 4 400.0000n 4 402.0000n 0 1300.0000n 0 1302.0000n 4 2200.0000n 4 2202.0000n 0 2500.0000n 0 2502.0000n 4 2800.0000n 4 2802.0000n 0 3700.0000n 0 3702.0000n 4 4600.0000n 4 4602.0000n 0)
Rdrv src dout 20.0
Cdout dout 0 2p
Rt4 dout tm2 0.006155
Lt4 tm2 t3 0.827077n
Ct4 t3 0 0.153357p
Rt7 t3 tm5 0.006155
Lt7 tm5 t6 0.827077n
Ct7 t6 0 0.153357p
Rt10 t6 tm8 0.006155
Lt10 tm8 t9 0.827077n
Ct10 t9 0 0.153357p
Rt13 t9 tm11 0.006155
Lt13 tm11 t12 0.827077n
Ct13 t12 0 0.153357p
Rt16 t12 tm14 0.006155
Lt16 tm14 t15 0.827077n
Ct16 t15 0 0.153357p
Rt19 t15 tm17 0.006155
Lt19 tm17 t18 0.827077n
Ct19 t18 0 0.153357p
Rt22 t18 tm20 0.006155
Lt22 tm20 t21 0.827077n
Ct22 t21 0 0.153357p
Rt24 t21 tm23 0.006155
Lt24 tm23 p1 0.827077n
Ct24 p1 0 0.153357p
Lv26 p1 v25 1.358n
Cv26 v25 0 0.4885p
Rt29 v25 tm28 0.000108591
Lt29 tm28 p27 0.0226227n
Ct29 p27 0 0.00825347p
Rt33 p27 tm31 0.00636161
Lt33 tm31 t32 0.85484n
Ct33 t32 0 0.158504p
Rt36 t32 tm34 0.00636161
Lt36 tm34 t35 0.85484n
Ct36 t35 0 0.158504p
Rt39 t35 tm37 0.00636161
Lt39 tm37 t38 0.85484n
Ct39 t38 0 0.158504p
Rt42 t38 tm40 0.00636161
Lt42 tm40 t41 0.85484n
Ct42 t41 0 0.158504p
Rt45 t41 tm43 0.00636161
Lt45 tm43 t44 0.85484n
Ct45 t44 0 0.158504p
Rt48 t44 tm46 0.00636161
Lt48 tm46 t47 0.85484n
Ct48 t47 0 0.158504p
Rt51 t47 tm49 0.00636161
Lt51 tm49 t50 0.85484n
Ct51 t50 0 0.158504p
Rt54 t50 tm52 0.00636161
Lt54 tm52 t53 0.85484n
Ct54 t53 0 0.158504p
Rt57 t53 tm55 0.00636161
Lt57 tm55 t56 0.85484n
Ct57 t56 0 0.158504p
Rt60 t56 tm58 0.00636161
Lt60 tm58 t59 0.85484n
Ct60 t59 0 0.158504p
Rt63 t59 tm61 0.00636161
Lt63 tm61 t62 0.85484n
Ct63 t62 0 0.158504p
Rt66 t62 tm64 0.00636161
Lt66 tm64 t65 0.85484n
Ct66 t65 0 0.158504p
Rt69 t65 tm67 0.00636161
Lt69 tm67 t68 0.85484n
Ct69 t68 0 0.158504p
Rt72 t68 tm70 0.00636161
Lt72 tm70 t71 0.85484n
Ct72 t71 0 0.158504p
Rt75 t71 tm73 0.00636161
Lt75 tm73 t74 0.85484n
Ct75 t74 0 0.158504p
Rt78 t74 tm76 0.00636161
Lt78 tm76 t77 0.85484n
Ct78 t77 0 0.158504p
Rt81 t77 tm79 0.00636161
Lt81 tm79 t80 0.85484n
Ct81 t80 0 0.158504p
Rt84 t80 tm82 0.00636161
Lt84 tm82 t83 0.85484n
Ct84 t83 0 0.158504p
Rt87 t83 tm85 0.00636161
Lt87 tm85 t86 0.85484n
Ct87 t86 0 0.158504p
Rt90 t86 tm88 0.00636161
Lt90 tm88 t89 0.85484n
Ct90 t89 0 0.158504p
Rt93 t89 tm91 0.00636161
Lt93 tm91 t92 0.85484n
Ct93 t92 0 0.158504p
Rt96 t92 tm94 0.00636161
Lt96 tm94 t95 0.85484n
Ct96 t95 0 0.158504p
Rt99 t95 tm97 0.00636161
Lt99 tm97 t98 0.85484n
Ct99 t98 0 0.158504p
Rt101 t98 tm100 0.00636161
Lt101 tm100 p30 0.85484n
Ct101 p30 0 0.158504p
Lv103 p30 v102 1.358n
Cv103 v102 0 0.4885p
Rt106 v102 tm105 0.00447425
Lt106 tm105 p104 0.601226n
Ct106 p104 0 0.111479p
Lv108 p104 v107 1.358n
Cv108 v107 0 0.4885p
Rt112 v107 tm110 0.00642912
Lt112 tm110 t111 0.863912n
Ct112 t111 0 0.160187p
Rt115 t111 tm113 0.00642912
Lt115 tm113 t114 0.863912n
Ct115 t114 0 0.160187p
Rt118 t114 tm116 0.00642912
Lt118 tm116 t117 0.863912n
Ct118 t117 0 0.160187p
Rt121 t117 tm119 0.00642912
Lt121 tm119 t120 0.863912n
Ct121 t120 0 0.160187p
Rt124 t120 tm122 0.00642912
Lt124 tm122 t123 0.863912n
Ct124 t123 0 0.160187p
Rt127 t123 tm125 0.00642912
Lt127 tm125 t126 0.863912n
Ct127 t126 0 0.160187p
Rt130 t126 tm128 0.00642912
Lt130 tm128 t129 0.863912n
Ct130 t129 0 0.160187p
Rt133 t129 tm131 0.00642912
Lt133 tm131 t132 0.863912n
Ct133 t132 0 0.160187p
Rt136 t132 tm134 0.00642912
Lt136 tm134 t135 0.863912n
Ct136 t135 0 0.160187p
Rt139 t135 tm137 0.00642912
Lt139 tm137 t138 0.863912n
Ct139 t138 0 0.160187p
Rt142 t138 tm140 0.00642912
Lt142 tm140 t141 0.863912n
Ct142 t141 0 0.160187p
Rt144 t141 tm143 0.00642912
Lt144 tm143 p109 0.863912n
Ct144 p109 0 0.160187p
Lv146 p109 v145 1.358n
Cv146 v145 0 0.4885p
Rt149 v145 tm147 0.00595977
Lt149 tm147 t148 0.800844n
Ct149 t148 0 0.148492p
Rt152 t148 tm150 0.00595977
Lt152 tm150 t151 0.800844n
Ct152 t151 0 0.148492p
Rt155 t151 tm153 0.00595977
Lt155 tm153 t154 0.800844n
Ct155 t154 0 0.148492p
Rt158 t154 tm156 0.00595977
Lt158 tm156 t157 0.800844n
Ct158 t157 0 0.148492p
Rt161 t157 tm159 0.00595977
Lt161 tm159 t160 0.800844n
Ct161 t160 0 0.148492p
Rt164 t160 tm162 0.00595977
Lt164 tm162 t163 0.800844n
Ct164 t163 0 0.148492p
Rt167 t163 tm165 0.00595977
Lt167 tm165 t166 0.800844n
Ct167 t166 0 0.148492p
Rt170 t166 tm168 0.00595977
Lt170 tm168 t169 0.800844n
Ct170 t169 0 0.148492p
Rt173 t169 tm171 0.00595977
Lt173 tm171 t172 0.800844n
Ct173 t172 0 0.148492p
Rt175 t172 tm174 0.00595977
Lt175 tm174 din 0.800844n
Ct175 din 0 0.148492p
Cin din 0 5p
.tran 0.1n 5000n 0 0.2n
.control
set wr_singlescale
set wr_vecnames
set numdgt=7
run

wrdata /out/led_hop01_fast.txt v(dout) v(din)
.endc
.end
