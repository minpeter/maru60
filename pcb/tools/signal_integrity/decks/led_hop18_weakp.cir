* led_hop18_weakp: SK6805 DOUT (assumed 1000 ohm, 30 ns) -> 100 ohm in series -> routed hop -> DIN 15 pF
Vsrc src 0 PWL(0.0000n 0 100.0000n 0 130.0000n 4 400.0000n 4 430.0000n 0 1300.0000n 0 1330.0000n 4 2200.0000n 4 2230.0000n 0 2500.0000n 0 2530.0000n 4 2800.0000n 4 2830.0000n 0 3700.0000n 0 3730.0000n 4 4600.0000n 4 4630.0000n 0)
Rdrv src dout 1000.0
Cdout dout 0 2p
Rt4 dout tm2 0.00641571
Lt4 tm2 t3 0.86211n
Ct4 t3 0 0.159852p
Rt7 t3 tm5 0.00641571
Lt7 tm5 t6 0.86211n
Ct7 t6 0 0.159852p
Rt10 t6 tm8 0.00641571
Lt10 tm8 t9 0.86211n
Ct10 t9 0 0.159852p
Rt12 t9 tm11 0.00641571
Lt12 tm11 p1 0.86211n
Ct12 p1 0 0.159852p
Rt15 p1 tm14 0.00122857
Lt15 tm14 p13 0.195251n
Ct15 p13 0 0.0465124p
Rt18 p13 tm17 0.000347492
Lt18 tm17 p16 0.0552252n
Ct18 p16 0 0.0131557p
Rt21 p16 tm20 0.00172
Lt21 tm20 p19 0.273351n
Ct21 p19 0 0.0651174p
Rt25 p19 tm23 0.00373554
Lt25 tm23 t24 0.593671n
Ct25 t24 0 0.141424p
Rt28 t24 tm26 0.00373554
Lt28 tm26 t27 0.593671n
Ct28 t27 0 0.141424p
Rt31 t27 tm29 0.00373554
Lt31 tm29 t30 0.593671n
Ct31 t30 0 0.141424p
Rt33 t30 tm32 0.00373554
Lt33 tm32 p22 0.593671n
Ct33 p22 0 0.141424p
Rt36 p22 tm35 0.000491429
Lt36 tm35 p34 0.0781003n
Ct36 p34 0 0.018605p
Rt40 p34 tm38 0.00330118
Lt40 tm38 t39 0.524639n
Ct40 t39 0 0.124979p
Rt42 t39 tm41 0.00330118
Lt42 tm41 p37 0.524639n
Ct42 p37 0 0.124979p
Lv44 p37 v43 1.358n
Cv44 v43 0 0.4885p
Rt46 v43 tm45 0.00191925
Lt46 tm45 rs_a 0.305016n
Ct46 rs_a 0 0.0726606p
Rser rs_a rs_b 100
Cser rs_b 0 0.1p
Rt49 rs_b tm48 0.00482473
Lt49 tm48 p47 0.76677n
Ct49 p47 0 0.182659p
Lv51 p47 v50 1.358n
Cv51 v50 0 0.4885p
Rt54 v50 tm52 0.00453592
Lt54 tm52 t53 0.720871n
Ct54 t53 0 0.171725p
Rt57 t53 tm55 0.00453592
Lt57 tm55 t56 0.720871n
Ct57 t56 0 0.171725p
Rt60 t56 tm58 0.00453592
Lt60 tm58 t59 0.720871n
Ct60 t59 0 0.171725p
Rt62 t59 tm61 0.00453592
Lt62 tm61 din 0.720871n
Ct62 din 0 0.171725p
Cin din 0 15p
.tran 0.1n 5000n 0 0.2n
.control
set wr_singlescale
set wr_vecnames
set numdgt=7
run

wrdata /out/led_hop18_weakp.txt v(dout) v(din)
.endc
.end
