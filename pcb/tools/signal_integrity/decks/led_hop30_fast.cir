* led_hop30_fast: SK6805 DOUT (assumed 20 ohm, 2 ns) -> 100 ohm in series -> routed hop -> DIN 5 pF
Vsrc src 0 PWL(0.0000n 0 100.0000n 0 102.0000n 4 400.0000n 4 402.0000n 0 1300.0000n 0 1302.0000n 4 2200.0000n 4 2202.0000n 0 2500.0000n 0 2502.0000n 4 2800.0000n 4 2802.0000n 0 3700.0000n 0 3702.0000n 4 4600.0000n 4 4602.0000n 0)
Rdrv src dout 20.0
Cdout dout 0 2p
Rt4 dout tm2 0.00319429
Lt4 tm2 t3 0.507652n
Ct4 t3 0 0.120932p
Rt6 t3 tm5 0.00319429
Lt6 tm5 p1 0.507652n
Ct6 p1 0 0.120932p
Lv8 p1 v7 1.358n
Cv8 v7 0 0.4885p
Rt12 v7 tm10 0.00326583
Lt12 tm10 t11 0.593378n
Ct12 t11 0 0.170918p
Rt15 t11 tm13 0.00326583
Lt15 tm13 t14 0.593378n
Ct15 t14 0 0.170918p
Rt18 t14 tm16 0.00326583
Lt18 tm16 t17 0.593378n
Ct18 t17 0 0.170918p
Rt20 t17 tm19 0.00326583
Lt20 tm19 p9 0.593378n
Ct20 p9 0 0.170918p
Rt23 p9 tm22 1.08515e-05
Lt23 tm22 p21 0.00172457n
Ct23 p21 0 0.000410825p
Rs27 p21 sm25 0.00475048
Ls27 sm25 s26 0.754969n
Cs27 s26 0 0.179848p
Rs30 s26 sm28 0.00475048
Ls30 sm28 s29 0.754969n
Cs30 s29 0 0.179848p
Rs32 s29 sm31 0.00475048
Ls32 sm31 stubend24 0.754969n
Cs32 stubend24 0 0.179848p
Cs33 stubend24 0 0.15p
Rt35 p21 tm34 0.00154338
Lt35 tm34 rs_a 0.245281n
Ct35 rs_a 0 0.0584306p
Rser rs_a rs_b 100
Cser rs_b 0 0.1p
Rt38 rs_b tm37 0.00315228
Lt38 tm37 p36 0.500976n
Ct38 p36 0 0.119342p
Lv40 p36 v39 1.358n
Cv40 v39 0 0.4885p
Rt43 v39 tm41 0.00466209
Lt43 tm41 t42 0.740922n
Ct43 t42 0 0.176502p
Rt46 t42 tm44 0.00466209
Lt46 tm44 t45 0.740922n
Ct46 t45 0 0.176502p
Rt49 t45 tm47 0.00466209
Lt49 tm47 t48 0.740922n
Ct49 t48 0 0.176502p
Rt52 t48 tm50 0.00466209
Lt52 tm50 t51 0.740922n
Ct52 t51 0 0.176502p
Rt55 t51 tm53 0.00466209
Lt55 tm53 t54 0.740922n
Ct55 t54 0 0.176502p
Rt58 t54 tm56 0.00466209
Lt58 tm56 t57 0.740922n
Ct58 t57 0 0.176502p
Rt61 t57 tm59 0.00466209
Lt61 tm59 t60 0.740922n
Ct61 t60 0 0.176502p
Rt64 t60 tm62 0.00466209
Lt64 tm62 t63 0.740922n
Ct64 t63 0 0.176502p
Rt67 t63 tm65 0.00466209
Lt67 tm65 t66 0.740922n
Ct67 t66 0 0.176502p
Rt70 t66 tm68 0.00466209
Lt70 tm68 t69 0.740922n
Ct70 t69 0 0.176502p
Rt73 t69 tm71 0.00466209
Lt73 tm71 t72 0.740922n
Ct73 t72 0 0.176502p
Rt76 t72 tm74 0.00466209
Lt76 tm74 t75 0.740922n
Ct76 t75 0 0.176502p
Rt78 t75 tm77 0.00466209
Lt78 tm77 din 0.740922n
Ct78 din 0 0.176502p
Cin din 0 5p
.tran 0.1n 5000n 0 0.2n
.control
set wr_singlescale
set wr_vecnames
set numdgt=7
run

wrdata /out/led_hop30_fast.txt v(dout) v(din)
.endc
.end
