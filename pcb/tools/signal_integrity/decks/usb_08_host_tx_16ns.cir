* USB full speed, host_tx, source ramp 16 ns, cable 1 m
Rrxp pinp 0 10meg
Rrxm pinm 0 10meg
Cpinp pinp 0 5p
Cpinm pinm 0 5p
Vpu vpu 0 3.3
Rpu vpu pinp 1.5k
Rt3 pinp tm1 0.00437464
Lt3 tm1 t2 0.587841n
Ct3 t2 0 0.108998p
Rt6 t2 tm4 0.00437464
Lt6 tm4 t5 0.587841n
Ct6 t5 0 0.108998p
Rt8 t5 tm7 0.00437464
Lt8 tm7 rp_a 0.587841n
Ct8 rp_a 0 0.108998p
Rt11 pinm tm10 0.00298827
Lt11 tm10 phy9 0.401549n
Ct11 phy9 0 0.0744552p
Lv13 phy9 phy12 1.358n
Cv13 phy12 0 0.4885p
Rt17 phy12 tm15 0.00570972
Lt17 tm15 t16 0.767242n
Ct17 t16 0 0.142262p
Rt20 t16 tm18 0.00570972
Lt20 tm18 t19 0.767242n
Ct20 t19 0 0.142262p
Rt22 t19 tm21 0.00570972
Lt22 tm21 phy14 0.767242n
Ct22 phy14 0 0.142262p
Lv24 phy14 phy23 1.358n
Cv24 phy23 0 0.4885p
Rt26 phy23 tm25 0.00195699
Lt26 tm25 rm_a 0.26297n
Ct26 rm_a 0 0.0487599p
R102 rp_a rp_b 27
R103 rm_a rm_b 27
Rt31 conp tm30 0.0030141
Lt31 tm30 u29 0.405019n
Ct31 u29 0 0.0750985p
Lv33 u29 u32 1.358n
Cv33 u32 0 0.4885p
Rt36 u32 tm34 0.00352901
Lt36 tm34 t35 0.474211n
Ct36 t35 0 0.0879281p
Rt38 t35 tm37 0.00352901
Lt38 tm37 dp27 0.474211n
Ct38 dp27 0 0.0879281p
Rt41 conm tm40 0.00582544
Lt41 tm40 u39 0.782792n
Ct41 u39 0 0.145145p
Lv42 u39 dm28 1.358n
Cv42 dm28 0 0.4885p
Rp1a49 dp27 p1ra50 0.00498468
Rp1b49 dm28 p1rb51 0.00498468
Lp1a49 p1ra50 p1a47 0.894673n
Lp1b49 p1rb51 p1b48 0.894673n
Kp149 Lp1a49 Lp1b49 0.22195
Cp1a49 p1a47 0 0.230461p
Cp1b49 p1b48 0 0.230461p
Cp1m49 p1a47 p1b48 0.0386324p
Rp1a54 p1a47 p1ra55 0.00498468
Rp1b54 p1b48 p1rb56 0.00498468
Lp1a54 p1ra55 p1a52 0.894673n
Lp1b54 p1rb56 p1b53 0.894673n
Kp154 Lp1a54 Lp1b54 0.22195
Cp1a54 p1a52 0 0.230461p
Cp1b54 p1b53 0 0.230461p
Cp1m54 p1a52 p1b53 0.0386324p
Rp1a59 p1a52 p1ra60 0.00498468
Rp1b59 p1b53 p1rb61 0.00498468
Lp1a59 p1ra60 p1a57 0.894673n
Lp1b59 p1rb61 p1b58 0.894673n
Kp159 Lp1a59 Lp1b59 0.22195
Cp1a59 p1a57 0 0.230461p
Cp1b59 p1b58 0 0.230461p
Cp1m59 p1a57 p1b58 0.0386324p
Rp1a64 p1a57 p1ra65 0.00498468
Rp1b64 p1b58 p1rb66 0.00498468
Lp1a64 p1ra65 p1a62 0.894673n
Lp1b64 p1rb66 p1b63 0.894673n
Kp164 Lp1a64 Lp1b64 0.22195
Cp1a64 p1a62 0 0.230461p
Cp1b64 p1b63 0 0.230461p
Cp1m64 p1a62 p1b63 0.0386324p
Rp1a67 p1a62 p1ra68 0.00498468
Rp1b67 p1b63 p1rb69 0.00498468
Lp1a67 p1ra68 dpx45 0.894673n
Lp1b67 p1rb69 dmx46 0.894673n
Kp167 Lp1a67 Lp1b67 0.22195
Cp1a67 dpx45 0 0.230461p
Cp1b67 dmx46 0 0.230461p
Cp1m67 dpx45 dmx46 0.0386324p
Rt71 dpx45 tm70 0.000557144
Lt71 tm70 dp43 0.101229n
Ct71 dp43 0 0.0291583p
Rj72 dmx46 dm44 1m
Lv75 dp43 dp73 1.358n
Cv75 dp73 0 0.4885p
Lv76 dm44 dm74 1.358n
Cv76 dm74 0 0.4885p
Rp3a83 dp73 p3ra84 0.00459922
Rp3b83 dm74 p3rb85 0.00459922
Lp3a83 p3ra84 p3a81 0.825489n
Lp3b83 p3rb85 p3b82 0.825489n
Kp383 Lp3a83 Lp3b83 0.22195
Cp3a83 p3a81 0 0.212639p
Cp3b83 p3b82 0 0.212639p
Cp3m83 p3a81 p3b82 0.035645p
Rp3a88 p3a81 p3ra89 0.00459922
Rp3b88 p3b82 p3rb90 0.00459922
Lp3a88 p3ra89 p3a86 0.825489n
Lp3b88 p3rb90 p3b87 0.825489n
Kp388 Lp3a88 Lp3b88 0.22195
Cp3a88 p3a86 0 0.212639p
Cp3b88 p3b87 0 0.212639p
Cp3m88 p3a86 p3b87 0.035645p
Rp3a91 p3a86 p3ra92 0.00459922
Rp3b91 p3b87 p3rb93 0.00459922
Lp3a91 p3ra92 dpx79 0.825489n
Lp3b91 p3rb93 dmx80 0.825489n
Kp391 Lp3a91 Lp3b91 0.22195
Cp3a91 dpx79 0 0.212639p
Cp3b91 dmx80 0 0.212639p
Cp3m91 dpx79 dmx80 0.035645p
Rj94 dpx79 dp77 1m
Rt96 dmx80 tm95 0.000544267
Lt96 tm95 dm78 0.0988895n
Ct96 dm78 0 0.0284844p
Lv99 dp77 dp97 1.358n
Cv99 dp97 0 0.4885p
Lv100 dm78 dm98 1.358n
Cv100 dm98 0 0.4885p
Rp5a107 dp97 p5ra108 0.00542598
Rp5b107 dm98 p5rb109 0.00542598
Lp5a107 p5ra108 p5a105 0.97388n
Lp5b107 p5rb109 p5b106 0.97388n
Kp5107 Lp5a107 Lp5b107 0.22195
Cp5a107 p5a105 0 0.250864p
Cp5b107 p5b106 0 0.250864p
Cp5m107 p5a105 p5b106 0.0420527p
Rp5a112 p5a105 p5ra113 0.00542598
Rp5b112 p5b106 p5rb114 0.00542598
Lp5a112 p5ra113 p5a110 0.97388n
Lp5b112 p5rb114 p5b111 0.97388n
Kp5112 Lp5a112 Lp5b112 0.22195
Cp5a112 p5a110 0 0.250864p
Cp5b112 p5b111 0 0.250864p
Cp5m112 p5a110 p5b111 0.0420527p
Rp5a117 p5a110 p5ra118 0.00542598
Rp5b117 p5b111 p5rb119 0.00542598
Lp5a117 p5ra118 p5a115 0.97388n
Lp5b117 p5rb119 p5b116 0.97388n
Kp5117 Lp5a117 Lp5b117 0.22195
Cp5a117 p5a115 0 0.250864p
Cp5b117 p5b116 0 0.250864p
Cp5m117 p5a115 p5b116 0.0420527p
Rp5a122 p5a115 p5ra123 0.00542598
Rp5b122 p5b116 p5rb124 0.00542598
Lp5a122 p5ra123 p5a120 0.97388n
Lp5b122 p5rb124 p5b121 0.97388n
Kp5122 Lp5a122 Lp5b122 0.22195
Cp5a122 p5a120 0 0.250864p
Cp5b122 p5b121 0 0.250864p
Cp5m122 p5a120 p5b121 0.0420527p
Rp5a127 p5a120 p5ra128 0.00542598
Rp5b127 p5b121 p5rb129 0.00542598
Lp5a127 p5ra128 p5a125 0.97388n
Lp5b127 p5rb129 p5b126 0.97388n
Kp5127 Lp5a127 Lp5b127 0.22195
Cp5a127 p5a125 0 0.250864p
Cp5b127 p5b126 0 0.250864p
Cp5m127 p5a125 p5b126 0.0420527p
Rp5a132 p5a125 p5ra133 0.00542598
Rp5b132 p5b126 p5rb134 0.00542598
Lp5a132 p5ra133 p5a130 0.97388n
Lp5b132 p5rb134 p5b131 0.97388n
Kp5132 Lp5a132 Lp5b132 0.22195
Cp5a132 p5a130 0 0.250864p
Cp5b132 p5b131 0 0.250864p
Cp5m132 p5a130 p5b131 0.0420527p
Rp5a135 p5a130 p5ra136 0.00542598
Rp5b135 p5b131 p5rb137 0.00542598
Lp5a135 p5ra136 dpx103 0.97388n
Lp5b135 p5rb137 dmx104 0.97388n
Kp5135 Lp5a135 Lp5b135 0.22195
Cp5a135 dpx103 0 0.250864p
Cp5b135 dmx104 0 0.250864p
Cp5m135 dpx103 dmx104 0.0420527p
Rt139 dpx103 tm138 0.000628371
Lt139 tm138 dp101 0.114171n
Ct139 dp101 0 0.032886p
Rj140 dmx104 dm102 1m
Lv142 dp101 u141 1.358n
Cv142 u141 0 0.4885p
Rt144 u141 tm143 0.00243101
Lt144 tm143 rp_b 0.326667n
Ct144 rp_b 0 0.0605706p
Lv146 dm102 u145 1.358n
Cv146 u145 0 0.4885p
Rt148 u145 tm147 0.00283083
Lt148 tm147 rm_b 0.380392n
Ct148 rm_b 0 0.0705322p
Cu10p conp 0 0.7p
Cu10m conm 0 0.7p
Rst152 conp stm150 0.00551383
Lst152 stm150 st151 0.74092n
Cst152 st151 0 0.137381p
Rst155 st151 stm153 0.00551383
Lst155 stm153 st154 0.74092n
Cst155 st154 0 0.137381p
Rst157 st154 stm156 0.00551383
Lst157 stm156 st149 0.74092n
Cst157 st149 0 0.137381p
Cst158 st149 0 0.3p
Rst162 conm stm160 0.00548216
Lst162 stm160 st161 0.736664n
Cst162 st161 0 0.136592p
Rst165 st161 stm163 0.00548216
Lst165 stm163 st164 0.736664n
Cst165 st164 0 0.136592p
Rst167 st164 stm166 0.00548216
Lst167 stm166 st159 0.736664n
Cst167 st159 0 0.136592p
Cst168 st159 0 0.3p
Cconp conp 0 0.6p
Cconm conm 0 0.6p
Rcbp0 conp cb169 4.6m
Lcbp0 cb169 cb170 4.68n
Ccbp0 cb170 0 2.3111p
Rcbp1 cb170 cb171 4.6m
Lcbp1 cb171 cb172 4.68n
Ccbp1 cb172 0 2.3111p
Rcbp2 cb172 cb173 4.6m
Lcbp2 cb173 cb174 4.68n
Ccbp2 cb174 0 2.3111p
Rcbp3 cb174 cb175 4.6m
Lcbp3 cb175 cb176 4.68n
Ccbp3 cb176 0 2.3111p
Rcbp4 cb176 cb177 4.6m
Lcbp4 cb177 cb178 4.68n
Ccbp4 cb178 0 2.3111p
Rcbp5 cb178 cb179 4.6m
Lcbp5 cb179 cb180 4.68n
Ccbp5 cb180 0 2.3111p
Rcbp6 cb180 cb181 4.6m
Lcbp6 cb181 cb182 4.68n
Ccbp6 cb182 0 2.3111p
Rcbp7 cb182 cb183 4.6m
Lcbp7 cb183 cb184 4.68n
Ccbp7 cb184 0 2.3111p
Rcbp8 cb184 cb185 4.6m
Lcbp8 cb185 cb186 4.68n
Ccbp8 cb186 0 2.3111p
Rcbp9 cb186 cb187 4.6m
Lcbp9 cb187 cb188 4.68n
Ccbp9 cb188 0 2.3111p
Rcbp10 cb188 cb189 4.6m
Lcbp10 cb189 cb190 4.68n
Ccbp10 cb190 0 2.3111p
Rcbp11 cb190 cb191 4.6m
Lcbp11 cb191 cb192 4.68n
Ccbp11 cb192 0 2.3111p
Rcbp12 cb192 cb193 4.6m
Lcbp12 cb193 cb194 4.68n
Ccbp12 cb194 0 2.3111p
Rcbp13 cb194 cb195 4.6m
Lcbp13 cb195 cb196 4.68n
Ccbp13 cb196 0 2.3111p
Rcbp14 cb196 cb197 4.6m
Lcbp14 cb197 cb198 4.68n
Ccbp14 cb198 0 2.3111p
Rcbp15 cb198 cb199 4.6m
Lcbp15 cb199 cb200 4.68n
Ccbp15 cb200 0 2.3111p
Rcbp16 cb200 cb201 4.6m
Lcbp16 cb201 cb202 4.68n
Ccbp16 cb202 0 2.3111p
Rcbp17 cb202 cb203 4.6m
Lcbp17 cb203 cb204 4.68n
Ccbp17 cb204 0 2.3111p
Rcbp18 cb204 cb205 4.6m
Lcbp18 cb205 cb206 4.68n
Ccbp18 cb206 0 2.3111p
Rcbp19 cb206 cb207 4.6m
Lcbp19 cb207 cb208 4.68n
Ccbp19 cb208 0 2.3111p
Rcbp20 cb208 cb209 4.6m
Lcbp20 cb209 cb210 4.68n
Ccbp20 cb210 0 2.3111p
Rcbp21 cb210 cb211 4.6m
Lcbp21 cb211 cb212 4.68n
Ccbp21 cb212 0 2.3111p
Rcbp22 cb212 cb213 4.6m
Lcbp22 cb213 cb214 4.68n
Ccbp22 cb214 0 2.3111p
Rcbp23 cb214 cb215 4.6m
Lcbp23 cb215 cb216 4.68n
Ccbp23 cb216 0 2.3111p
Rcbp24 cb216 cb217 4.6m
Lcbp24 cb217 cb218 4.68n
Ccbp24 cb218 0 2.3111p
Rcbp25 cb218 cb219 4.6m
Lcbp25 cb219 cb220 4.68n
Ccbp25 cb220 0 2.3111p
Rcbp26 cb220 cb221 4.6m
Lcbp26 cb221 cb222 4.68n
Ccbp26 cb222 0 2.3111p
Rcbp27 cb222 cb223 4.6m
Lcbp27 cb223 cb224 4.68n
Ccbp27 cb224 0 2.3111p
Rcbp28 cb224 cb225 4.6m
Lcbp28 cb225 cb226 4.68n
Ccbp28 cb226 0 2.3111p
Rcbp29 cb226 cb227 4.6m
Lcbp29 cb227 cb228 4.68n
Ccbp29 cb228 0 2.3111p
Rcbp30 cb228 cb229 4.6m
Lcbp30 cb229 cb230 4.68n
Ccbp30 cb230 0 2.3111p
Rcbp31 cb230 cb231 4.6m
Lcbp31 cb231 cb232 4.68n
Ccbp31 cb232 0 2.3111p
Rcbp32 cb232 cb233 4.6m
Lcbp32 cb233 cb234 4.68n
Ccbp32 cb234 0 2.3111p
Rcbp33 cb234 cb235 4.6m
Lcbp33 cb235 cb236 4.68n
Ccbp33 cb236 0 2.3111p
Rcbp34 cb236 cb237 4.6m
Lcbp34 cb237 cb238 4.68n
Ccbp34 cb238 0 2.3111p
Rcbp35 cb238 cb239 4.6m
Lcbp35 cb239 cb240 4.68n
Ccbp35 cb240 0 2.3111p
Rcbp36 cb240 cb241 4.6m
Lcbp36 cb241 cb242 4.68n
Ccbp36 cb242 0 2.3111p
Rcbp37 cb242 cb243 4.6m
Lcbp37 cb243 cb244 4.68n
Ccbp37 cb244 0 2.3111p
Rcbp38 cb244 cb245 4.6m
Lcbp38 cb245 cb246 4.68n
Ccbp38 cb246 0 2.3111p
Rcbp39 cb246 cb247 4.6m
Lcbp39 cb247 cb248 4.68n
Ccbp39 cb248 0 2.3111p
Rcbp40 cb248 cb249 4.6m
Lcbp40 cb249 cb250 4.68n
Ccbp40 cb250 0 2.3111p
Rcbp41 cb250 cb251 4.6m
Lcbp41 cb251 cb252 4.68n
Ccbp41 cb252 0 2.3111p
Rcbp42 cb252 cb253 4.6m
Lcbp42 cb253 cb254 4.68n
Ccbp42 cb254 0 2.3111p
Rcbp43 cb254 cb255 4.6m
Lcbp43 cb255 cb256 4.68n
Ccbp43 cb256 0 2.3111p
Rcbp44 cb256 cb257 4.6m
Lcbp44 cb257 cb258 4.68n
Ccbp44 cb258 0 2.3111p
Rcbp45 cb258 cb259 4.6m
Lcbp45 cb259 cb260 4.68n
Ccbp45 cb260 0 2.3111p
Rcbp46 cb260 cb261 4.6m
Lcbp46 cb261 cb262 4.68n
Ccbp46 cb262 0 2.3111p
Rcbp47 cb262 cb263 4.6m
Lcbp47 cb263 cb264 4.68n
Ccbp47 cb264 0 2.3111p
Rcbp48 cb264 cb265 4.6m
Lcbp48 cb265 cb266 4.68n
Ccbp48 cb266 0 2.3111p
Rcbp49 cb266 cb267 4.6m
Lcbp49 cb267 hp 4.68n
Ccbp49 hp 0 2.3111p
Rcbm0 conm cb268 4.6m
Lcbm0 cb268 cb269 4.68n
Ccbm0 cb269 0 2.3111p
Rcbm1 cb269 cb270 4.6m
Lcbm1 cb270 cb271 4.68n
Ccbm1 cb271 0 2.3111p
Rcbm2 cb271 cb272 4.6m
Lcbm2 cb272 cb273 4.68n
Ccbm2 cb273 0 2.3111p
Rcbm3 cb273 cb274 4.6m
Lcbm3 cb274 cb275 4.68n
Ccbm3 cb275 0 2.3111p
Rcbm4 cb275 cb276 4.6m
Lcbm4 cb276 cb277 4.68n
Ccbm4 cb277 0 2.3111p
Rcbm5 cb277 cb278 4.6m
Lcbm5 cb278 cb279 4.68n
Ccbm5 cb279 0 2.3111p
Rcbm6 cb279 cb280 4.6m
Lcbm6 cb280 cb281 4.68n
Ccbm6 cb281 0 2.3111p
Rcbm7 cb281 cb282 4.6m
Lcbm7 cb282 cb283 4.68n
Ccbm7 cb283 0 2.3111p
Rcbm8 cb283 cb284 4.6m
Lcbm8 cb284 cb285 4.68n
Ccbm8 cb285 0 2.3111p
Rcbm9 cb285 cb286 4.6m
Lcbm9 cb286 cb287 4.68n
Ccbm9 cb287 0 2.3111p
Rcbm10 cb287 cb288 4.6m
Lcbm10 cb288 cb289 4.68n
Ccbm10 cb289 0 2.3111p
Rcbm11 cb289 cb290 4.6m
Lcbm11 cb290 cb291 4.68n
Ccbm11 cb291 0 2.3111p
Rcbm12 cb291 cb292 4.6m
Lcbm12 cb292 cb293 4.68n
Ccbm12 cb293 0 2.3111p
Rcbm13 cb293 cb294 4.6m
Lcbm13 cb294 cb295 4.68n
Ccbm13 cb295 0 2.3111p
Rcbm14 cb295 cb296 4.6m
Lcbm14 cb296 cb297 4.68n
Ccbm14 cb297 0 2.3111p
Rcbm15 cb297 cb298 4.6m
Lcbm15 cb298 cb299 4.68n
Ccbm15 cb299 0 2.3111p
Rcbm16 cb299 cb300 4.6m
Lcbm16 cb300 cb301 4.68n
Ccbm16 cb301 0 2.3111p
Rcbm17 cb301 cb302 4.6m
Lcbm17 cb302 cb303 4.68n
Ccbm17 cb303 0 2.3111p
Rcbm18 cb303 cb304 4.6m
Lcbm18 cb304 cb305 4.68n
Ccbm18 cb305 0 2.3111p
Rcbm19 cb305 cb306 4.6m
Lcbm19 cb306 cb307 4.68n
Ccbm19 cb307 0 2.3111p
Rcbm20 cb307 cb308 4.6m
Lcbm20 cb308 cb309 4.68n
Ccbm20 cb309 0 2.3111p
Rcbm21 cb309 cb310 4.6m
Lcbm21 cb310 cb311 4.68n
Ccbm21 cb311 0 2.3111p
Rcbm22 cb311 cb312 4.6m
Lcbm22 cb312 cb313 4.68n
Ccbm22 cb313 0 2.3111p
Rcbm23 cb313 cb314 4.6m
Lcbm23 cb314 cb315 4.68n
Ccbm23 cb315 0 2.3111p
Rcbm24 cb315 cb316 4.6m
Lcbm24 cb316 cb317 4.68n
Ccbm24 cb317 0 2.3111p
Rcbm25 cb317 cb318 4.6m
Lcbm25 cb318 cb319 4.68n
Ccbm25 cb319 0 2.3111p
Rcbm26 cb319 cb320 4.6m
Lcbm26 cb320 cb321 4.68n
Ccbm26 cb321 0 2.3111p
Rcbm27 cb321 cb322 4.6m
Lcbm27 cb322 cb323 4.68n
Ccbm27 cb323 0 2.3111p
Rcbm28 cb323 cb324 4.6m
Lcbm28 cb324 cb325 4.68n
Ccbm28 cb325 0 2.3111p
Rcbm29 cb325 cb326 4.6m
Lcbm29 cb326 cb327 4.68n
Ccbm29 cb327 0 2.3111p
Rcbm30 cb327 cb328 4.6m
Lcbm30 cb328 cb329 4.68n
Ccbm30 cb329 0 2.3111p
Rcbm31 cb329 cb330 4.6m
Lcbm31 cb330 cb331 4.68n
Ccbm31 cb331 0 2.3111p
Rcbm32 cb331 cb332 4.6m
Lcbm32 cb332 cb333 4.68n
Ccbm32 cb333 0 2.3111p
Rcbm33 cb333 cb334 4.6m
Lcbm33 cb334 cb335 4.68n
Ccbm33 cb335 0 2.3111p
Rcbm34 cb335 cb336 4.6m
Lcbm34 cb336 cb337 4.68n
Ccbm34 cb337 0 2.3111p
Rcbm35 cb337 cb338 4.6m
Lcbm35 cb338 cb339 4.68n
Ccbm35 cb339 0 2.3111p
Rcbm36 cb339 cb340 4.6m
Lcbm36 cb340 cb341 4.68n
Ccbm36 cb341 0 2.3111p
Rcbm37 cb341 cb342 4.6m
Lcbm37 cb342 cb343 4.68n
Ccbm37 cb343 0 2.3111p
Rcbm38 cb343 cb344 4.6m
Lcbm38 cb344 cb345 4.68n
Ccbm38 cb345 0 2.3111p
Rcbm39 cb345 cb346 4.6m
Lcbm39 cb346 cb347 4.68n
Ccbm39 cb347 0 2.3111p
Rcbm40 cb347 cb348 4.6m
Lcbm40 cb348 cb349 4.68n
Ccbm40 cb349 0 2.3111p
Rcbm41 cb349 cb350 4.6m
Lcbm41 cb350 cb351 4.68n
Ccbm41 cb351 0 2.3111p
Rcbm42 cb351 cb352 4.6m
Lcbm42 cb352 cb353 4.68n
Ccbm42 cb353 0 2.3111p
Rcbm43 cb353 cb354 4.6m
Lcbm43 cb354 cb355 4.68n
Ccbm43 cb355 0 2.3111p
Rcbm44 cb355 cb356 4.6m
Lcbm44 cb356 cb357 4.68n
Ccbm44 cb357 0 2.3111p
Rcbm45 cb357 cb358 4.6m
Lcbm45 cb358 cb359 4.68n
Ccbm45 cb359 0 2.3111p
Rcbm46 cb359 cb360 4.6m
Lcbm46 cb360 cb361 4.68n
Ccbm46 cb361 0 2.3111p
Rcbm47 cb361 cb362 4.6m
Lcbm47 cb362 cb363 4.68n
Ccbm47 cb363 0 2.3111p
Rcbm48 cb363 cb364 4.6m
Lcbm48 cb364 cb365 4.68n
Ccbm48 cb365 0 2.3111p
Rcbm49 cb365 cb366 4.6m
Lcbm49 cb366 hm 4.68n
Ccbm49 hm 0 2.3111p
Chp hp 0 20.0p
Chm hm 0 20.0p
Rhp hp 0 15k
Rhm hm 0 15k
Vhp shp 0 PWL(0.0000n 3.3 325.3333n 3.3 341.3333n 0 408.6667n 0 424.6667n 3.3 492.0000n 3.3 508.0000n 0 575.3333n 0 591.3333n 3.3 658.6667n 3.3 674.6667n 0 742.0000n 0 758.0000n 3.3 825.3333n 3.3 841.3333n 0 992.0000n 0 1008.0000n 3.3 1075.3333n 3.3 1091.3333n 0 1325.3333n 0 1341.3333n 3.3 1492.0000n 3.3 1508.0000n 0 1575.3333n 0 1591.3333n 3.3 2158.6667n 3.3 2174.6667n 0 2242.0000n 0 2258.0000n 3.3 2325.3333n 3.3 2341.3333n 0 2908.6667n 0 2924.6667n 3.3 2992.0000n 3.3 3008.0000n 0 3075.3333n 0 3091.3333n 3.3 3242.0000n 3.3 3258.0000n 0 3408.6667n 0 3424.6667n 3.3 3658.6667n 3.3 3674.6667n 0 3992.0000n 0 4008.0000n 3.3 4075.3333n 3.3 4091.3333n 0 4158.6667n 0 4174.6667n 3.3 4575.3333n 3.3 4591.3333n 0 4658.6667n 0 4674.6667n 3.3 4742.0000n 3.3 4758.0000n 0 4908.6667n 0 4924.6667n 3.3 5075.3333n 3.3 5091.3333n 0 5158.6667n 0 5174.6667n 3.3)
Vhm shm 0 PWL(0.0000n 0 325.3333n 0 341.3333n 3.3 408.6667n 3.3 424.6667n 0 492.0000n 0 508.0000n 3.3 575.3333n 3.3 591.3333n 0 658.6667n 0 674.6667n 3.3 742.0000n 3.3 758.0000n 0 825.3333n 0 841.3333n 3.3 992.0000n 3.3 1008.0000n 0 1075.3333n 0 1091.3333n 3.3 1325.3333n 3.3 1341.3333n 0 1492.0000n 0 1508.0000n 3.3 1575.3333n 3.3 1591.3333n 0 2158.6667n 0 2174.6667n 3.3 2242.0000n 3.3 2258.0000n 0 2325.3333n 0 2341.3333n 3.3 2908.6667n 3.3 2924.6667n 0 2992.0000n 0 3008.0000n 3.3 3075.3333n 3.3 3091.3333n 0 3242.0000n 0 3258.0000n 3.3 3408.6667n 3.3 3424.6667n 0 3658.6667n 0 3674.6667n 3.3 3992.0000n 3.3 4008.0000n 0 4075.3333n 0 4091.3333n 3.3 4158.6667n 3.3 4174.6667n 0 4575.3333n 0 4591.3333n 3.3 4658.6667n 3.3 4674.6667n 0 4742.0000n 0 4758.0000n 3.3 4908.6667n 3.3 4924.6667n 0 5075.3333n 0 5091.3333n 3.3 5158.6667n 3.3 5174.6667n 0)
Rhdp shp hp 36
Rhdm shm hm 36
.options method=gear reltol=2e-3
.tran 0.1n 5333.3n 0 0.2n
.control
set wr_singlescale
set wr_vecnames
set numdgt=7
run

wrdata /out/usb_08_host_tx_16ns.txt v(pinp) v(pinm) v(conp) v(conm)
.endc
.end
