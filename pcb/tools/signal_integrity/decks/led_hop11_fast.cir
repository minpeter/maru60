* led_hop11_fast: SK6805 DOUT (assumed 20 ohm, 2 ns) -> routed hop -> DIN 5 pF
Vsrc src 0 PWL(0.0000n 0 100.0000n 0 102.0000n 4 400.0000n 4 402.0000n 0 1300.0000n 0 1302.0000n 4 2200.0000n 4 2202.0000n 0 2500.0000n 0 2502.0000n 4 2800.0000n 4 2802.0000n 0 3700.0000n 0 3702.0000n 4 4600.0000n 4 4602.0000n 0)
Rdrv src dout 20.0
Cdout dout 0 2p
Rt4 dout tm2 0.00349492
Lt4 tm2 t3 0.635003n
Ct4 t3 0 0.182908p
Rt7 t3 tm5 0.00349492
Lt7 tm5 t6 0.635003n
Ct7 t6 0 0.182908p
Rt10 t6 tm8 0.00349492
Lt10 tm8 t9 0.635003n
Ct10 t9 0 0.182908p
Rt13 t9 tm11 0.00349492
Lt13 tm11 t12 0.635003n
Ct13 t12 0 0.182908p
Rt16 t12 tm14 0.00349492
Lt16 tm14 t15 0.635003n
Ct16 t15 0 0.182908p
Rt19 t15 tm17 0.00349492
Lt19 tm17 t18 0.635003n
Ct19 t18 0 0.182908p
Rt21 t18 tm20 0.00349492
Lt21 tm20 p1 0.635003n
Ct21 p1 0 0.182908p
Lv23 p1 v22 1.358n
Cv23 v22 0 0.4885p
Rt26 v22 tm25 1.08539e-05
Lt26 tm25 p24 0.00172496n
Ct26 p24 0 0.000410918p
Rs30 p24 sm28 0.00320043
Ls30 sm28 s29 0.508628n
Cs30 s29 0 0.121165p
Rs32 s29 sm31 0.00320043
Ls32 sm31 stubend27 0.508628n
Cs32 stubend27 0 0.121165p
Cs33 stubend27 0 0.15p
Rt36 p24 tm34 0.0049126
Lt36 tm34 t35 0.780734n
Ct36 t35 0 0.185986p
Rt39 t35 tm37 0.0049126
Lt39 tm37 t38 0.780734n
Ct39 t38 0 0.185986p
Rt42 t38 tm40 0.0049126
Lt42 tm40 t41 0.780734n
Ct42 t41 0 0.185986p
Rt45 t41 tm43 0.0049126
Lt45 tm43 t44 0.780734n
Ct45 t44 0 0.185986p
Rt48 t44 tm46 0.0049126
Lt48 tm46 t47 0.780734n
Ct48 t47 0 0.185986p
Rt51 t47 tm49 0.0049126
Lt51 tm49 t50 0.780734n
Ct51 t50 0 0.185986p
Rt54 t50 tm52 0.0049126
Lt54 tm52 t53 0.780734n
Ct54 t53 0 0.185986p
Rt57 t53 tm55 0.0049126
Lt57 tm55 t56 0.780734n
Ct57 t56 0 0.185986p
Rt60 t56 tm58 0.0049126
Lt60 tm58 t59 0.780734n
Ct60 t59 0 0.185986p
Rt63 t59 tm61 0.0049126
Lt63 tm61 t62 0.780734n
Ct63 t62 0 0.185986p
Rt66 t62 tm64 0.0049126
Lt66 tm64 t65 0.780734n
Ct66 t65 0 0.185986p
Rt69 t65 tm67 0.0049126
Lt69 tm67 t68 0.780734n
Ct69 t68 0 0.185986p
Rt72 t68 tm70 0.0049126
Lt72 tm70 t71 0.780734n
Ct72 t71 0 0.185986p
Rt75 t71 tm73 0.0049126
Lt75 tm73 t74 0.780734n
Ct75 t74 0 0.185986p
Rt77 t74 tm76 0.0049126
Lt77 tm76 din 0.780734n
Ct77 din 0 0.185986p
Cin din 0 5p
.tran 0.1n 5000n 0 0.2n
.control
set wr_singlescale
set wr_vecnames
set numdgt=7
run

wrdata /out/led_hop11_fast.txt v(dout) v(din)
.endc
.end
