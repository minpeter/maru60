* led_hop07_fast: SK6805 DOUT (assumed 20 ohm, 2 ns) -> routed hop -> DIN 5 pF
Vsrc src 0 PWL(0.0000n 0 100.0000n 0 102.0000n 4 400.0000n 4 402.0000n 0 1300.0000n 0 1302.0000n 4 2200.0000n 4 2202.0000n 0 2500.0000n 0 2502.0000n 4 2800.0000n 4 2802.0000n 0 3700.0000n 0 3702.0000n 4 4600.0000n 4 4602.0000n 0)
Rdrv src dout 20.0
Cdout dout 0 2p
Rt4 dout tm2 0.00401129
Lt4 tm2 t3 0.637493n
Ct4 t3 0 0.151863p
Rt7 t3 tm5 0.00401129
Lt7 tm5 t6 0.637493n
Ct7 t6 0 0.151863p
Rt10 t6 tm8 0.00401129
Lt10 tm8 t9 0.637493n
Ct10 t9 0 0.151863p
Rt12 t9 tm11 0.00401129
Lt12 tm11 p1 0.637493n
Ct12 p1 0 0.151863p
Rs16 p1 sm14 0.00437781
Ls16 sm14 s15 0.695743n
Cs16 s15 0 0.165739p
Rs19 s15 sm17 0.00437781
Ls19 sm17 s18 0.695743n
Cs19 s18 0 0.165739p
Rs22 s18 sm20 0.00437781
Ls22 sm20 s21 0.695743n
Cs22 s21 0 0.165739p
Rs25 s21 sm23 0.00437781
Ls25 sm23 s24 0.695743n
Cs25 s24 0 0.165739p
Rs28 s24 sm26 0.00437781
Ls28 sm26 s27 0.695743n
Cs28 s27 0 0.165739p
Rs31 s27 sm29 0.00437781
Ls31 sm29 s30 0.695743n
Cs31 s30 0 0.165739p
Rs34 s30 sm32 0.00437781
Ls34 sm32 s33 0.695743n
Cs34 s33 0 0.165739p
Rs37 s33 sm35 0.00437781
Ls37 sm35 s36 0.695743n
Cs37 s36 0 0.165739p
Rs39 s36 sm38 0.00437781
Ls39 sm38 stubend13 0.695743n
Cs39 stubend13 0 0.165739p
Cs40 stubend13 0 0.15p
Rt43 p1 tm42 0.000129895
Lt43 tm42 p41 0.0206436n
Ct43 p41 0 0.0049177p
Rt46 p41 tm44 0.00343201
Lt46 tm44 t45 0.623572n
Ct46 t45 0 0.179615p
Rt49 t45 tm47 0.00343201
Lt49 tm47 t48 0.623572n
Ct49 t48 0 0.179615p
Rt52 t48 tm50 0.00343201
Lt52 tm50 t51 0.623572n
Ct52 t51 0 0.179615p
Rt55 t51 tm53 0.00343201
Lt55 tm53 t54 0.623572n
Ct55 t54 0 0.179615p
Rt57 t54 tm56 0.00343201
Lt57 tm56 din 0.623572n
Ct57 din 0 0.179615p
Cin din 0 5p
.tran 0.1n 5000n 0 0.2n
.control
set wr_singlescale
set wr_vecnames
set numdgt=7
run

wrdata /out/led_hop07_fast.txt v(dout) v(din)
.endc
.end
