* led_hop07_fast: SK6805 DOUT (assumed 20 ohm, 2 ns) -> 100 ohm in series -> routed hop -> DIN 5 pF
Vsrc src 0 PWL(0.0000n 0 100.0000n 0 102.0000n 4 400.0000n 4 402.0000n 0 1300.0000n 0 1302.0000n 4 2200.0000n 4 2202.0000n 0 2500.0000n 0 2502.0000n 4 2800.0000n 4 2802.0000n 0 3700.0000n 0 3702.0000n 4 4600.0000n 4 4602.0000n 0)
Rdrv src dout 20.0
Cdout dout 0 2p
Rt2 dout tm1 0.00509656
Lt2 tm1 rs_a 0.684849n
Ct2 rs_a 0 0.126985p
Rser rs_a rs_b 100
Cser rs_b 0 0.1p
Rt6 rs_b tm4 0.00481595
Lt6 tm4 t5 0.647142n
Ct6 t5 0 0.119993p
Rt8 t5 tm7 0.00481595
Lt8 tm7 p3 0.647142n
Ct8 p3 0 0.119993p
Lv10 p3 v9 1.358n
Cv10 v9 0 0.4885p
Rt14 v9 tm12 0.0064118
Lt14 tm12 t13 0.861585n
Ct14 t13 0 0.159755p
Rt17 t13 tm15 0.0064118
Lt17 tm15 t16 0.861585n
Ct17 t16 0 0.159755p
Rt20 t16 tm18 0.0064118
Lt20 tm18 t19 0.861585n
Ct20 t19 0 0.159755p
Rt23 t19 tm21 0.0064118
Lt23 tm21 t22 0.861585n
Ct23 t22 0 0.159755p
Rt26 t22 tm24 0.0064118
Lt26 tm24 t25 0.861585n
Ct26 t25 0 0.159755p
Rt29 t25 tm27 0.0064118
Lt29 tm27 t28 0.861585n
Ct29 t28 0 0.159755p
Rt32 t28 tm30 0.0064118
Lt32 tm30 t31 0.861585n
Ct32 t31 0 0.159755p
Rt35 t31 tm33 0.0064118
Lt35 tm33 t34 0.861585n
Ct35 t34 0 0.159755p
Rt38 t34 tm36 0.0064118
Lt38 tm36 t37 0.861585n
Ct38 t37 0 0.159755p
Rt41 t37 tm39 0.0064118
Lt41 tm39 t40 0.861585n
Ct41 t40 0 0.159755p
Rt44 t40 tm42 0.0064118
Lt44 tm42 t43 0.861585n
Ct44 t43 0 0.159755p
Rt47 t43 tm45 0.0064118
Lt47 tm45 t46 0.861585n
Ct47 t46 0 0.159755p
Rt50 t46 tm48 0.0064118
Lt50 tm48 t49 0.861585n
Ct50 t49 0 0.159755p
Rt53 t49 tm51 0.0064118
Lt53 tm51 t52 0.861585n
Ct53 t52 0 0.159755p
Rt56 t52 tm54 0.0064118
Lt56 tm54 t55 0.861585n
Ct56 t55 0 0.159755p
Rt59 t55 tm57 0.0064118
Lt59 tm57 t58 0.861585n
Ct59 t58 0 0.159755p
Rt62 t58 tm60 0.0064118
Lt62 tm60 t61 0.861585n
Ct62 t61 0 0.159755p
Rt65 t61 tm63 0.0064118
Lt65 tm63 t64 0.861585n
Ct65 t64 0 0.159755p
Rt68 t64 tm66 0.0064118
Lt68 tm66 t67 0.861585n
Ct68 t67 0 0.159755p
Rt71 t67 tm69 0.0064118
Lt71 tm69 t70 0.861585n
Ct71 t70 0 0.159755p
Rt74 t70 tm72 0.0064118
Lt74 tm72 t73 0.861585n
Ct74 t73 0 0.159755p
Rt77 t73 tm75 0.0064118
Lt77 tm75 t76 0.861585n
Ct77 t76 0 0.159755p
Rt80 t76 tm78 0.0064118
Lt80 tm78 t79 0.861585n
Ct80 t79 0 0.159755p
Rt83 t79 tm81 0.0064118
Lt83 tm81 t82 0.861585n
Ct83 t82 0 0.159755p
Rt86 t82 tm84 0.0064118
Lt86 tm84 t85 0.861585n
Ct86 t85 0 0.159755p
Rt89 t85 tm87 0.0064118
Lt89 tm87 t88 0.861585n
Ct89 t88 0 0.159755p
Rt92 t88 tm90 0.0064118
Lt92 tm90 t91 0.861585n
Ct92 t91 0 0.159755p
Rt95 t91 tm93 0.0064118
Lt95 tm93 t94 0.861585n
Ct95 t94 0 0.159755p
Rt97 t94 tm96 0.0064118
Lt97 tm96 p11 0.861585n
Ct97 p11 0 0.159755p
Lv99 p11 v98 1.358n
Cv99 v98 0 0.4885p
Rt101 v98 tm100 0.00242904
Lt101 tm100 din 0.326402n
Ct101 din 0 0.0605214p
Cin din 0 5p
.tran 0.1n 5000n 0 0.2n
.control
set wr_singlescale
set wr_vecnames
set numdgt=7
run

wrdata /out/led_hop07_fast.txt v(dout) v(din)
.endc
.end
