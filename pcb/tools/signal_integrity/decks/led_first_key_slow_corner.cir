* led_first_key_slow_corner: RP2350 GPIO -> SN74LV1T125 at 4.0 V -> 330R -> first LED (slow corner)
Vsrc src 0 PWL(0.0000n 0 100.0000n 0 101.5000n 3.3 400.0000n 3.3 401.5000n 0 1300.0000n 0 1301.5000n 3.3 2200.0000n 3.3 2201.5000n 0 2500.0000n 0 2501.5000n 3.3 2800.0000n 3.3 2801.5000n 0 3700.0000n 0 3701.5000n 3.3 4600.0000n 3.3 4601.5000n 0)
Rgpio src gpio 125
Cgpio gpio 0 3p
Rt4 gpio tm2 0.00492981
Lt4 tm2 t3 0.662442n
Ct4 t3 0 0.12283p
Rt7 t3 tm5 0.00492981
Lt7 tm5 t6 0.662442n
Ct7 t6 0 0.12283p
Rt9 t6 tm8 0.00492981
Lt9 tm8 p1 0.662442n
Ct9 p1 0 0.12283p
Lv11 p1 v10 1.358n
Cv11 v10 0 0.4885p
Rt15 v10 tm13 0.00590928
Lt15 tm13 t14 0.794059n
Ct15 t14 0 0.147234p
Rt18 t14 tm16 0.00590928
Lt18 tm16 t17 0.794059n
Ct18 t17 0 0.147234p
Rt21 t17 tm19 0.00590928
Lt21 tm19 t20 0.794059n
Ct21 t20 0 0.147234p
Rt23 t20 tm22 0.00590928
Lt23 tm22 p12 0.794059n
Ct23 p12 0 0.147234p
Lv25 p12 v24 1.358n
Cv25 v24 0 0.4885p
Rt28 v24 tm26 0.00519894
Lt28 tm26 t27 0.698607n
Ct28 t27 0 0.129536p
Rt31 t27 tm29 0.00519894
Lt31 tm29 t30 0.698607n
Ct31 t30 0 0.129536p
Rt33 t30 tm32 0.00519894
Lt33 tm32 bufin 0.698607n
Ct33 bufin 0 0.129536p
Cbufin bufin 0 10p
Bthr thr 0 V=4.0/(1+exp(-(v(bufin)-1.75)/0.03))
Rthr thr dly_in 50
Tdly dly_in 0 dly_out 0 Z0=50 TD=6.5n
Rdly dly_out 0 50
Eshp shp 0 dly_out 0 2
Rshp shp shpc 1k
Cshp shpc 0 1.364p
Ebuf bufi 0 shpc 0 1
Rbuf bufi bufout 100
Cbufout bufout 0 2.5p
Rt37 bufout tm35 0.0033334
Lt37 tm35 t36 0.447925n
Ct37 t36 0 0.0830543p
Rt39 t36 tm38 0.0033334
Lt39 tm38 p34 0.447925n
Ct39 p34 0 0.0830543p
Lv41 p34 v40 1.358n
Cv41 v40 0 0.4885p
Rt45 v40 tm43 0.00555868
Lt45 tm43 t44 0.746947n
Ct45 t44 0 0.138499p
Rt48 t44 tm46 0.00555868
Lt48 tm46 t47 0.746947n
Ct48 t47 0 0.138499p
Rt51 t47 tm49 0.00555868
Lt51 tm49 t50 0.746947n
Ct51 t50 0 0.138499p
Rt54 t50 tm52 0.00555868
Lt54 tm52 t53 0.746947n
Ct54 t53 0 0.138499p
Rt56 t53 tm55 0.00555868
Lt56 tm55 p42 0.746947n
Ct56 p42 0 0.138499p
Lv58 p42 v57 1.358n
Cv58 v57 0 0.4885p
Rt60 v57 tm59 0.00393143
Lt60 tm59 rin 0.528285n
Ct60 rin 0 0.0979546p
R110 rin rout 330
Crpad rout 0 0.1p
Rt64 rout tm62 0.00462481
Lt64 tm62 t63 0.621458n
Ct64 t63 0 0.115231p
Rt67 t63 tm65 0.00462481
Lt67 tm65 t66 0.621458n
Ct67 t66 0 0.115231p
Rt69 t66 tm68 0.00462481
Lt69 tm68 p61 0.621458n
Ct69 p61 0 0.115231p
Lv71 p61 v70 1.358n
Cv71 v70 0 0.4885p
Rt75 v70 tm73 0.00636827
Lt75 tm73 t74 0.855735n
Ct75 t74 0 0.15867p
Rt78 t74 tm76 0.00636827
Lt78 tm76 t77 0.855735n
Ct78 t77 0 0.15867p
Rt81 t77 tm79 0.00636827
Lt81 tm79 t80 0.855735n
Ct81 t80 0 0.15867p
Rt84 t80 tm82 0.00636827
Lt84 tm82 t83 0.855735n
Ct84 t83 0 0.15867p
Rt87 t83 tm85 0.00636827
Lt87 tm85 t86 0.855735n
Ct87 t86 0 0.15867p
Rt90 t86 tm88 0.00636827
Lt90 tm88 t89 0.855735n
Ct90 t89 0 0.15867p
Rt93 t89 tm91 0.00636827
Lt93 tm91 t92 0.855735n
Ct93 t92 0 0.15867p
Rt96 t92 tm94 0.00636827
Lt96 tm94 t95 0.855735n
Ct96 t95 0 0.15867p
Rt98 t95 tm97 0.00636827
Lt98 tm97 p72 0.855735n
Ct98 p72 0 0.15867p
Lv100 p72 v99 1.358n
Cv100 v99 0 0.4885p
Rt104 v99 tm102 0.00631248
Lt104 tm102 t103 0.848239n
Ct104 t103 0 0.15728p
Rt107 t103 tm105 0.00631248
Lt107 tm105 t106 0.848239n
Ct107 t106 0 0.15728p
Rt110 t106 tm108 0.00631248
Lt110 tm108 t109 0.848239n
Ct110 t109 0 0.15728p
Rt113 t109 tm111 0.00631248
Lt113 tm111 t112 0.848239n
Ct113 t112 0 0.15728p
Rt116 t112 tm114 0.00631248
Lt116 tm114 t115 0.848239n
Ct116 t115 0 0.15728p
Rt119 t115 tm117 0.00631248
Lt119 tm117 t118 0.848239n
Ct119 t118 0 0.15728p
Rt122 t118 tm120 0.00631248
Lt122 tm120 t121 0.848239n
Ct122 t121 0 0.15728p
Rt125 t121 tm123 0.00631248
Lt125 tm123 t124 0.848239n
Ct125 t124 0 0.15728p
Rt128 t124 tm126 0.00631248
Lt128 tm126 t127 0.848239n
Ct128 t127 0 0.15728p
Rt131 t127 tm129 0.00631248
Lt131 tm129 t130 0.848239n
Ct131 t130 0 0.15728p
Rt134 t130 tm132 0.00631248
Lt134 tm132 t133 0.848239n
Ct134 t133 0 0.15728p
Rt137 t133 tm135 0.00631248
Lt137 tm135 t136 0.848239n
Ct137 t136 0 0.15728p
Rt140 t136 tm138 0.00631248
Lt140 tm138 t139 0.848239n
Ct140 t139 0 0.15728p
Rt143 t139 tm141 0.00631248
Lt143 tm141 t142 0.848239n
Ct143 t142 0 0.15728p
Rt146 t142 tm144 0.00631248
Lt146 tm144 t145 0.848239n
Ct146 t145 0 0.15728p
Rt149 t145 tm147 0.00631248
Lt149 tm147 t148 0.848239n
Ct149 t148 0 0.15728p
Rt152 t148 tm150 0.00631248
Lt152 tm150 t151 0.848239n
Ct152 t151 0 0.15728p
Rt155 t151 tm153 0.00631248
Lt155 tm153 t154 0.848239n
Ct155 t154 0 0.15728p
Rt158 t154 tm156 0.00631248
Lt158 tm156 t157 0.848239n
Ct158 t157 0 0.15728p
Rt161 t157 tm159 0.00631248
Lt161 tm159 t160 0.848239n
Ct161 t160 0 0.15728p
Rt164 t160 tm162 0.00631248
Lt164 tm162 t163 0.848239n
Ct164 t163 0 0.15728p
Rt166 t163 tm165 0.00631248
Lt166 tm165 p101 0.848239n
Ct166 p101 0 0.15728p
Lv168 p101 v167 1.358n
Cv168 v167 0 0.4885p
Rt172 v167 tm170 0.00607812
Lt172 tm170 t171 0.816746n
Ct172 t171 0 0.151441p
Rt175 t171 tm173 0.00607812
Lt175 tm173 t174 0.816746n
Ct175 t174 0 0.151441p
Rt178 t174 tm176 0.00607812
Lt178 tm176 t177 0.816746n
Ct178 t177 0 0.151441p
Rt181 t177 tm179 0.00607812
Lt181 tm179 t180 0.816746n
Ct181 t180 0 0.151441p
Rt184 t180 tm182 0.00607812
Lt184 tm182 t183 0.816746n
Ct184 t183 0 0.151441p
Rt187 t183 tm185 0.00607812
Lt187 tm185 t186 0.816746n
Ct187 t186 0 0.151441p
Rt190 t186 tm188 0.00607812
Lt190 tm188 t189 0.816746n
Ct190 t189 0 0.151441p
Rt193 t189 tm191 0.00607812
Lt193 tm191 t192 0.816746n
Ct193 t192 0 0.151441p
Rt195 t192 tm194 0.00607812
Lt195 tm194 p169 0.816746n
Ct195 p169 0 0.151441p
Lv197 p169 v196 1.358n
Cv197 v196 0 0.4885p
Rt201 v196 tm199 0.00651388
Lt201 tm199 t200 0.875302n
Ct201 t200 0 0.162298p
Rt204 t200 tm202 0.00651388
Lt204 tm202 t203 0.875302n
Ct204 t203 0 0.162298p
Rt207 t203 tm205 0.00651388
Lt207 tm205 t206 0.875302n
Ct207 t206 0 0.162298p
Rt210 t206 tm208 0.00651388
Lt210 tm208 t209 0.875302n
Ct210 t209 0 0.162298p
Rt213 t209 tm211 0.00651388
Lt213 tm211 t212 0.875302n
Ct213 t212 0 0.162298p
Rt216 t212 tm214 0.00651388
Lt216 tm214 t215 0.875302n
Ct216 t215 0 0.162298p
Rt219 t215 tm217 0.00651388
Lt219 tm217 t218 0.875302n
Ct219 t218 0 0.162298p
Rt221 t218 tm220 0.00651388
Lt221 tm220 p198 0.875302n
Ct221 p198 0 0.162298p
Lv223 p198 v222 1.358n
Cv223 v222 0 0.4885p
Rt227 v222 tm225 0.00627052
Lt227 tm225 t226 0.842601n
Ct227 t226 0 0.156235p
Rt230 t226 tm228 0.00627052
Lt230 tm228 t229 0.842601n
Ct230 t229 0 0.156235p
Rt233 t229 tm231 0.00627052
Lt233 tm231 t232 0.842601n
Ct233 t232 0 0.156235p
Rt236 t232 tm234 0.00627052
Lt236 tm234 t235 0.842601n
Ct236 t235 0 0.156235p
Rt239 t235 tm237 0.00627052
Lt239 tm237 t238 0.842601n
Ct239 t238 0 0.156235p
Rt241 t238 tm240 0.00627052
Lt241 tm240 p224 0.842601n
Ct241 p224 0 0.156235p
Lv243 p224 v242 1.358n
Cv243 v242 0 0.4885p
Rt247 v242 tm245 0.00618853
Lt247 tm245 t246 0.831583n
Ct247 t246 0 0.154192p
Rt250 t246 tm248 0.00618853
Lt250 tm248 t249 0.831583n
Ct250 t249 0 0.154192p
Rt253 t249 tm251 0.00618853
Lt253 tm251 t252 0.831583n
Ct253 t252 0 0.154192p
Rt256 t252 tm254 0.00618853
Lt256 tm254 t255 0.831583n
Ct256 t255 0 0.154192p
Rt259 t255 tm257 0.00618853
Lt259 tm257 t258 0.831583n
Ct259 t258 0 0.154192p
Rt262 t258 tm260 0.00618853
Lt262 tm260 t261 0.831583n
Ct262 t261 0 0.154192p
Rt265 t261 tm263 0.00618853
Lt265 tm263 t264 0.831583n
Ct265 t264 0 0.154192p
Rt267 t264 tm266 0.00618853
Lt267 tm266 p244 0.831583n
Ct267 p244 0 0.154192p
Lv269 p244 v268 1.358n
Cv269 v268 0 0.4885p
Rt272 v268 tm270 0.00654521
Lt272 tm270 t271 0.879511n
Ct272 t271 0 0.163079p
Rt275 t271 tm273 0.00654521
Lt275 tm273 t274 0.879511n
Ct275 t274 0 0.163079p
Rt278 t274 tm276 0.00654521
Lt278 tm276 t277 0.879511n
Ct278 t277 0 0.163079p
Rt281 t277 tm279 0.00654521
Lt281 tm279 t280 0.879511n
Ct281 t280 0 0.163079p
Rt284 t280 tm282 0.00654521
Lt284 tm282 t283 0.879511n
Ct284 t283 0 0.163079p
Rt287 t283 tm285 0.00654521
Lt287 tm285 t286 0.879511n
Ct287 t286 0 0.163079p
Rt289 t286 tm288 0.00654521
Lt289 tm288 din 0.879511n
Ct289 din 0 0.163079p
Cin din 0 15p
.tran 0.1n 5000n 0 0.2n
.control
set wr_singlescale
set wr_vecnames
set numdgt=7
run

wrdata /out/led_first_key_slow_corner.txt v(gpio) v(bufin) v(bufout) v(din)
.endc
.end
