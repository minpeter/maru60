* led_hop19_weakp: SK6805 DOUT (assumed 1000 ohm, 30 ns) -> 100 ohm in series -> routed hop -> DIN 15 pF
Vsrc src 0 PWL(0.0000n 0 100.0000n 0 130.0000n 4 400.0000n 4 430.0000n 0 1300.0000n 0 1330.0000n 4 2200.0000n 4 2230.0000n 0 2500.0000n 0 2530.0000n 4 2800.0000n 4 2830.0000n 0 3700.0000n 0 3730.0000n 4 4600.0000n 4 4630.0000n 0)
Rdrv src dout 1000.0
Cdout dout 0 2p
Rt4 dout tm2 0.00380038
Lt4 tm2 t3 0.690502n
Ct4 t3 0 0.198894p
Rt7 t3 tm5 0.00380038
Lt7 tm5 t6 0.690502n
Ct7 t6 0 0.198894p
Rt9 t6 tm8 0.00380038
Lt9 tm8 p1 0.690502n
Ct9 p1 0 0.198894p
Rs13 p1 sm11 0.00454473
Ls13 sm11 s12 0.722271n
Cs13 s12 0 0.172059p
Rs16 s12 sm14 0.00454473
Ls16 sm14 s15 0.722271n
Cs16 s15 0 0.172059p
Rs19 s15 sm17 0.00454473
Ls19 sm17 s18 0.722271n
Cs19 s18 0 0.172059p
Rs22 s18 sm20 0.00454473
Ls22 sm20 s21 0.722271n
Cs22 s21 0 0.172059p
Rs24 s21 sm23 0.00454473
Ls24 sm23 stubend10 0.722271n
Cs24 stubend10 0 0.172059p
Cs25 stubend10 0 0.4885p
Cs26 stubend10 0 0.15p
Rt29 p1 tm28 5.23772e-18
Lt29 tm28 p27 9.51656e-16n
Ct29 p27 0 2.74118e-16p
Rt31 p27 tm30 0.00155423
Lt31 tm30 rs_a 0.247006n
Ct31 rs_a 0 0.0588414p
Rser rs_a rs_b 100
Cser rs_b 0 0.1p
Rt34 rs_b tm33 0.00315228
Lt34 tm33 p32 0.500976n
Ct34 p32 0 0.119342p
Lv36 p32 v35 1.358n
Cv36 v35 0 0.4885p
Rt39 v35 tm37 0.00466209
Lt39 tm37 t38 0.740922n
Ct39 t38 0 0.176502p
Rt42 t38 tm40 0.00466209
Lt42 tm40 t41 0.740922n
Ct42 t41 0 0.176502p
Rt45 t41 tm43 0.00466209
Lt45 tm43 t44 0.740922n
Ct45 t44 0 0.176502p
Rt48 t44 tm46 0.00466209
Lt48 tm46 t47 0.740922n
Ct48 t47 0 0.176502p
Rt51 t47 tm49 0.00466209
Lt51 tm49 t50 0.740922n
Ct51 t50 0 0.176502p
Rt54 t50 tm52 0.00466209
Lt54 tm52 t53 0.740922n
Ct54 t53 0 0.176502p
Rt57 t53 tm55 0.00466209
Lt57 tm55 t56 0.740922n
Ct57 t56 0 0.176502p
Rt60 t56 tm58 0.00466209
Lt60 tm58 t59 0.740922n
Ct60 t59 0 0.176502p
Rt63 t59 tm61 0.00466209
Lt63 tm61 t62 0.740922n
Ct63 t62 0 0.176502p
Rt66 t62 tm64 0.00466209
Lt66 tm64 t65 0.740922n
Ct66 t65 0 0.176502p
Rt69 t65 tm67 0.00466209
Lt69 tm67 t68 0.740922n
Ct69 t68 0 0.176502p
Rt72 t68 tm70 0.00466209
Lt72 tm70 t71 0.740922n
Ct72 t71 0 0.176502p
Rt74 t71 tm73 0.00466209
Lt74 tm73 din 0.740922n
Ct74 din 0 0.176502p
Cin din 0 15p
.tran 0.1n 5000n 0 0.2n
.control
set wr_singlescale
set wr_vecnames
set numdgt=7
run

wrdata /out/led_hop19_weakp.txt v(dout) v(din)
quit 0
.endc
.end
