Maru60 power tree (c) short on +4V_LED, averaged buck model
* 3V3 load i33a. LED_ENABLE goes high at ten. A 50 mOhm + 30 nH short to
* ground on +4V_LED closes at tsh [ASSUMED short impedance].
*   ten=6m tsh=0    : enabled into an existing short
*   ten=6m tsh=14m  : short applied to the running rail (LED load iled)
.param ten=6m
.param tsh=14m
.include models.lib
.include params.inc
.param cssx=10n
.param kdvdtx=50
.include board.inc
Vsrc src 0 pwl(0 0 10u 0 11u {vsrc})
XU18 vbk sw fb ss v4 0 tps62932_avg lnom={l2} kea={kea} vref={vref} iss={iss}
Vlen len 0 pwl(0 0 {ten} 0 {ten+1u} 3.3)
Vi33 i33cmd 0 {i33a}
Vled ledcmd 0 pwl(0 0 11m 0 11.001m {iled})
Vsh33 sh33 0 0
Vshl shled 0 pwl(0 0 {tsh} 0 {tsh+0.1u} 1)
.options method=gear reltol=1e-3 abstol=1e-9 vntol=1e-6 chgtol=1e-15 itl4=200
.ic v(v4)=0 v(v33)=0 v(vprot)=0
.control
set noaskquit
set wr_singlescale
set wr_vecnames
tran 0.05u 24m 0 1u uic
wrdata out.txt v(src) v(vbus) v(vfused) v(vprot) v(vbk) v(v4) v(v4b) v(v4c) v(v33) v(v33m) v(vled) i(Vsrc) i(L2) v(uvlo) v(ovlo) v(xu18.comp) v(xu8.en) v(dvdt) v(ss) i(Lsh) v(xu7.s)
quit
.endc
.end
