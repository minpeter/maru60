Maru60 power tree (d) brown-out, averaged buck model
* Source (behind rsrc): 5.0 V, settle; ramp to 4.2 V (20-25 ms), hold;
* ramp to 3.9 V (45-50 ms), hold; ramp to 3.3 V (70-90 ms), hold; ramp back
* to 5.0 V (110-130 ms). 3V3 load i33b; LED rail enabled at 4 ms with the
* drive current iled from 6 ms. Start-up shortened as in loadstep.inc; the
* restart after the under-voltage therefore also uses the short ramp.
.include models.lib
.include params.inc
.param cssx=10n
.param kdvdtx=50
.include board.inc
Vsrc src 0 pwl(0 0 10u 0 11u 5 20m 5 25m 4.2 45m 4.2 50m 3.9 70m 3.9 90m 3.3 110m 3.3 130m 5)
XU18 vbk sw fb ss v4 0 tps62932_avg lnom={l2} kea={kea} vref={vref} iss={iss}
Vlen len 0 pwl(0 0 4m 0 4.001m 3.3)
Vi33 i33cmd 0 {i33b}
Vled ledcmd 0 pwl(0 0 6m 0 6.001m {iled})
Vsh33 sh33 0 0
Vshl shled 0 0
.options method=gear reltol=1e-3 abstol=1e-9 vntol=1e-6 chgtol=1e-15 itl4=200
.ic v(v4)=0 v(v33)=0 v(vprot)=0
.control
set noaskquit
set wr_singlescale
set wr_vecnames
tran 1u 160m 0 5u uic
wrdata out.txt v(src) v(vbus) v(vfused) v(vprot) v(vbk) v(v4) v(v4b) v(v4c) v(v33) v(v33m) v(vled) i(Vsrc) i(L2) v(uvlo) v(ovlo) v(xu18.comp) v(xu8.en) v(dvdt) v(ss) v(xu18.d)
quit
.endc
.end
