* USB: propagation delay from the J1 pads to the RP2350 pins (one differential edge, matched ends)
Vp sp 0 PWL(0 0 2n 0 3n 3.3)
Vm sm 0 PWL(0 3.3 2n 3.3 3n 0)
Rsp sp conp 45
Rsm sm conm 45
Rtp pinp 0 20
Rtm pinm 0 20
Rt3 pinp tm1 0.00262478
Lt3 tm1 t2 0.352705n
Ct3 t2 0 0.0653985p
Rt6 t2 tm4 0.00262478
Lt6 tm4 t5 0.352705n
Ct6 t5 0 0.0653985p
Rt9 t5 tm7 0.00262478
Lt9 tm7 t8 0.352705n
Ct9 t8 0 0.0653985p
Rt12 t8 tm10 0.00262478
Lt12 tm10 t11 0.352705n
Ct12 t11 0 0.0653985p
Rt14 t11 tm13 0.00262478
Lt14 tm13 rp_a 0.352705n
Ct14 rp_a 0 0.0653985p
Rt17 pinm tm16 0.00298827
Lt17 tm16 phy15 0.401549n
Ct17 phy15 0 0.0744552p
Lv19 phy15 phy18 1.358n
Cv19 phy18 0 0.4885p
Rt23 phy18 tm21 0.00285486
Lt23 tm21 t22 0.383621n
Ct23 t22 0 0.071131p
Rt26 t22 tm24 0.00285486
Lt26 tm24 t25 0.383621n
Ct26 t25 0 0.071131p
Rt29 t25 tm27 0.00285486
Lt29 tm27 t28 0.383621n
Ct29 t28 0 0.071131p
Rt32 t28 tm30 0.00285486
Lt32 tm30 t31 0.383621n
Ct32 t31 0 0.071131p
Rt35 t31 tm33 0.00285486
Lt35 tm33 t34 0.383621n
Ct35 t34 0 0.071131p
Rt37 t34 tm36 0.00285486
Lt37 tm36 phy20 0.383621n
Ct37 phy20 0 0.071131p
Lv39 phy20 phy38 1.358n
Cv39 phy38 0 0.4885p
Rt41 phy38 tm40 0.00195699
Lt41 tm40 rm_a 0.26297n
Ct41 rm_a 0 0.0487599p
R102 rp_a rp_b 27
R103 rm_a rm_b 27
Rt46 conp tm45 0.0030141
Lt46 tm45 u44 0.405019n
Ct46 u44 0 0.0750985p
Lv48 u44 u47 1.358n
Cv48 u47 0 0.4885p
Rt51 u47 tm49 0.00352901
Lt51 tm49 t50 0.474211n
Ct51 t50 0 0.0879281p
Rt53 t50 tm52 0.00352901
Lt53 tm52 dp42 0.474211n
Ct53 dp42 0 0.0879281p
Rt56 conm tm55 0.00582544
Lt56 tm55 u54 0.782792n
Ct56 u54 0 0.145145p
Lv57 u54 dm43 1.358n
Cv57 dm43 0 0.4885p
Rp1a64 dp42 p1ra65 0.00498468
Rp1b64 dm43 p1rb66 0.00498468
Lp1a64 p1ra65 p1a62 0.894673n
Lp1b64 p1rb66 p1b63 0.894673n
Kp164 Lp1a64 Lp1b64 0.22195
Cp1a64 p1a62 0 0.230461p
Cp1b64 p1b63 0 0.230461p
Cp1m64 p1a62 p1b63 0.0386324p
Rp1a69 p1a62 p1ra70 0.00498468
Rp1b69 p1b63 p1rb71 0.00498468
Lp1a69 p1ra70 p1a67 0.894673n
Lp1b69 p1rb71 p1b68 0.894673n
Kp169 Lp1a69 Lp1b69 0.22195
Cp1a69 p1a67 0 0.230461p
Cp1b69 p1b68 0 0.230461p
Cp1m69 p1a67 p1b68 0.0386324p
Rp1a74 p1a67 p1ra75 0.00498468
Rp1b74 p1b68 p1rb76 0.00498468
Lp1a74 p1ra75 p1a72 0.894673n
Lp1b74 p1rb76 p1b73 0.894673n
Kp174 Lp1a74 Lp1b74 0.22195
Cp1a74 p1a72 0 0.230461p
Cp1b74 p1b73 0 0.230461p
Cp1m74 p1a72 p1b73 0.0386324p
Rp1a79 p1a72 p1ra80 0.00498468
Rp1b79 p1b73 p1rb81 0.00498468
Lp1a79 p1ra80 p1a77 0.894673n
Lp1b79 p1rb81 p1b78 0.894673n
Kp179 Lp1a79 Lp1b79 0.22195
Cp1a79 p1a77 0 0.230461p
Cp1b79 p1b78 0 0.230461p
Cp1m79 p1a77 p1b78 0.0386324p
Rp1a82 p1a77 p1ra83 0.00498468
Rp1b82 p1b78 p1rb84 0.00498468
Lp1a82 p1ra83 dpx60 0.894673n
Lp1b82 p1rb84 dmx61 0.894673n
Kp182 Lp1a82 Lp1b82 0.22195
Cp1a82 dpx60 0 0.230461p
Cp1b82 dmx61 0 0.230461p
Cp1m82 dpx60 dmx61 0.0386324p
Rt86 dpx60 tm85 0.000557144
Lt86 tm85 dp58 0.101229n
Ct86 dp58 0 0.0291583p
Rj87 dmx61 dm59 1m
Lv90 dp58 dp88 1.358n
Cv90 dp88 0 0.4885p
Lv91 dm59 dm89 1.358n
Cv91 dm89 0 0.4885p
Rp3a98 dp88 p3ra99 0.00459922
Rp3b98 dm89 p3rb100 0.00459922
Lp3a98 p3ra99 p3a96 0.825489n
Lp3b98 p3rb100 p3b97 0.825489n
Kp398 Lp3a98 Lp3b98 0.22195
Cp3a98 p3a96 0 0.212639p
Cp3b98 p3b97 0 0.212639p
Cp3m98 p3a96 p3b97 0.035645p
Rp3a103 p3a96 p3ra104 0.00459922
Rp3b103 p3b97 p3rb105 0.00459922
Lp3a103 p3ra104 p3a101 0.825489n
Lp3b103 p3rb105 p3b102 0.825489n
Kp3103 Lp3a103 Lp3b103 0.22195
Cp3a103 p3a101 0 0.212639p
Cp3b103 p3b102 0 0.212639p
Cp3m103 p3a101 p3b102 0.035645p
Rp3a106 p3a101 p3ra107 0.00459922
Rp3b106 p3b102 p3rb108 0.00459922
Lp3a106 p3ra107 dpx94 0.825489n
Lp3b106 p3rb108 dmx95 0.825489n
Kp3106 Lp3a106 Lp3b106 0.22195
Cp3a106 dpx94 0 0.212639p
Cp3b106 dmx95 0 0.212639p
Cp3m106 dpx94 dmx95 0.035645p
Rj109 dpx94 dp92 1m
Rt111 dmx95 tm110 0.000544267
Lt111 tm110 dm93 0.0988895n
Ct111 dm93 0 0.0284844p
Lv114 dp92 dp112 1.358n
Cv114 dp112 0 0.4885p
Lv115 dm93 dm113 1.358n
Cv115 dm113 0 0.4885p
Rp5a122 dp112 p5ra123 0.00542598
Rp5b122 dm113 p5rb124 0.00542598
Lp5a122 p5ra123 p5a120 0.97388n
Lp5b122 p5rb124 p5b121 0.97388n
Kp5122 Lp5a122 Lp5b122 0.22195
Cp5a122 p5a120 0 0.250864p
Cp5b122 p5b121 0 0.250864p
Cp5m122 p5a120 p5b121 0.0420527p
Rp5a127 p5a120 p5ra128 0.00542598
Rp5b127 p5b121 p5rb129 0.00542598
Lp5a127 p5ra128 p5a125 0.97388n
Lp5b127 p5rb129 p5b126 0.97388n
Kp5127 Lp5a127 Lp5b127 0.22195
Cp5a127 p5a125 0 0.250864p
Cp5b127 p5b126 0 0.250864p
Cp5m127 p5a125 p5b126 0.0420527p
Rp5a132 p5a125 p5ra133 0.00542598
Rp5b132 p5b126 p5rb134 0.00542598
Lp5a132 p5ra133 p5a130 0.97388n
Lp5b132 p5rb134 p5b131 0.97388n
Kp5132 Lp5a132 Lp5b132 0.22195
Cp5a132 p5a130 0 0.250864p
Cp5b132 p5b131 0 0.250864p
Cp5m132 p5a130 p5b131 0.0420527p
Rp5a137 p5a130 p5ra138 0.00542598
Rp5b137 p5b131 p5rb139 0.00542598
Lp5a137 p5ra138 p5a135 0.97388n
Lp5b137 p5rb139 p5b136 0.97388n
Kp5137 Lp5a137 Lp5b137 0.22195
Cp5a137 p5a135 0 0.250864p
Cp5b137 p5b136 0 0.250864p
Cp5m137 p5a135 p5b136 0.0420527p
Rp5a142 p5a135 p5ra143 0.00542598
Rp5b142 p5b136 p5rb144 0.00542598
Lp5a142 p5ra143 p5a140 0.97388n
Lp5b142 p5rb144 p5b141 0.97388n
Kp5142 Lp5a142 Lp5b142 0.22195
Cp5a142 p5a140 0 0.250864p
Cp5b142 p5b141 0 0.250864p
Cp5m142 p5a140 p5b141 0.0420527p
Rp5a147 p5a140 p5ra148 0.00542598
Rp5b147 p5b141 p5rb149 0.00542598
Lp5a147 p5ra148 p5a145 0.97388n
Lp5b147 p5rb149 p5b146 0.97388n
Kp5147 Lp5a147 Lp5b147 0.22195
Cp5a147 p5a145 0 0.250864p
Cp5b147 p5b146 0 0.250864p
Cp5m147 p5a145 p5b146 0.0420527p
Rp5a150 p5a145 p5ra151 0.00542598
Rp5b150 p5b146 p5rb152 0.00542598
Lp5a150 p5ra151 dpx118 0.97388n
Lp5b150 p5rb152 dmx119 0.97388n
Kp5150 Lp5a150 Lp5b150 0.22195
Cp5a150 dpx118 0 0.250864p
Cp5b150 dmx119 0 0.250864p
Cp5m150 dpx118 dmx119 0.0420527p
Rt154 dpx118 tm153 0.000628371
Lt154 tm153 dp116 0.114171n
Ct154 dp116 0 0.032886p
Rj155 dmx119 dm117 1m
Lv157 dp116 u156 1.358n
Cv157 u156 0 0.4885p
Rt159 u156 tm158 0.00243101
Lt159 tm158 rp_b 0.326667n
Ct159 rp_b 0 0.0605706p
Lv161 dm117 u160 1.358n
Cv161 u160 0 0.4885p
Rt163 u160 tm162 0.00283083
Lt163 tm162 rm_b 0.380392n
Ct163 rm_b 0 0.0705322p
Cu10p conp 0 0.7p
Cu10m conm 0 0.7p
Rst167 conp stm165 0.00551383
Lst167 stm165 st166 0.74092n
Cst167 st166 0 0.137381p
Rst170 st166 stm168 0.00551383
Lst170 stm168 st169 0.74092n
Cst170 st169 0 0.137381p
Rst172 st169 stm171 0.00551383
Lst172 stm171 st164 0.74092n
Cst172 st164 0 0.137381p
Cst173 st164 0 0.3p
Rst177 conm stm175 0.00551164
Lst177 stm175 st176 0.740626n
Cst177 st176 0 0.137327p
Rst180 st176 stm178 0.00551164
Lst180 stm178 st179 0.740626n
Cst180 st179 0 0.137327p
Rst182 st179 stm181 0.00551164
Lst182 stm181 st174 0.740626n
Cst182 st174 0 0.137327p
Cst183 st174 0 0.3p
Cconp conp 0 0.6p
Cconm conm 0 0.6p
.options method=gear reltol=1e-3
.tran 0.01n 8n 0 0.02n
.control
set wr_singlescale
set wr_vecnames
set numdgt=7
run

wrdata /out/usb_delay.txt v(conp) v(conm) v(pinp) v(pinm) v(rp_b) v(rm_b)
quit 0
.endc
.end
